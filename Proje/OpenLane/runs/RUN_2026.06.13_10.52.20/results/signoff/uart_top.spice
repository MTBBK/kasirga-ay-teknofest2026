* NGSPICE file created from uart_top.ext - technology: sky130A

* Black-box entry subcircuit for sky130_fd_sc_hd__clkbuf_1 abstract view
.subckt sky130_fd_sc_hd__clkbuf_1 A VGND VNB VPB VPWR X
.ends

* Black-box entry subcircuit for sky130_fd_sc_hd__and2_1 abstract view
.subckt sky130_fd_sc_hd__and2_1 A B VGND VNB VPB VPWR X
.ends

* Black-box entry subcircuit for sky130_fd_sc_hd__or2_1 abstract view
.subckt sky130_fd_sc_hd__or2_1 A B VGND VNB VPB VPWR X
.ends

* Black-box entry subcircuit for sky130_fd_sc_hd__tapvpwrvgnd_1 abstract view
.subckt sky130_fd_sc_hd__tapvpwrvgnd_1 VGND VPWR
.ends

* Black-box entry subcircuit for sky130_fd_sc_hd__o21ai_1 abstract view
.subckt sky130_fd_sc_hd__o21ai_1 A1 A2 B1 VGND VNB VPB VPWR Y
.ends

* Black-box entry subcircuit for sky130_fd_sc_hd__fill_2 abstract view
.subckt sky130_fd_sc_hd__fill_2 VGND VNB VPB VPWR
.ends

* Black-box entry subcircuit for sky130_fd_sc_hd__fill_1 abstract view
.subckt sky130_fd_sc_hd__fill_1 VGND VNB VPB VPWR
.ends

* Black-box entry subcircuit for sky130_fd_sc_hd__decap_4 abstract view
.subckt sky130_fd_sc_hd__decap_4 VGND VNB VPB VPWR
.ends

* Black-box entry subcircuit for sky130_fd_sc_hd__decap_6 abstract view
.subckt sky130_fd_sc_hd__decap_6 VGND VNB VPB VPWR
.ends

* Black-box entry subcircuit for sky130_fd_sc_hd__a22o_1 abstract view
.subckt sky130_fd_sc_hd__a22o_1 A1 A2 B1 B2 VGND VNB VPB VPWR X
.ends

* Black-box entry subcircuit for sky130_fd_sc_hd__o21a_1 abstract view
.subckt sky130_fd_sc_hd__o21a_1 A1 A2 B1 VGND VNB VPB VPWR X
.ends

* Black-box entry subcircuit for sky130_fd_sc_hd__nor2_2 abstract view
.subckt sky130_fd_sc_hd__nor2_2 A B VGND VNB VPB VPWR Y
.ends

* Black-box entry subcircuit for sky130_fd_sc_hd__clkbuf_2 abstract view
.subckt sky130_fd_sc_hd__clkbuf_2 A VGND VNB VPB VPWR X
.ends

* Black-box entry subcircuit for sky130_fd_sc_hd__a21o_1 abstract view
.subckt sky130_fd_sc_hd__a21o_1 A1 A2 B1 VGND VNB VPB VPWR X
.ends

* Black-box entry subcircuit for sky130_fd_sc_hd__nor2_1 abstract view
.subckt sky130_fd_sc_hd__nor2_1 A B VGND VNB VPB VPWR Y
.ends

* Black-box entry subcircuit for sky130_fd_sc_hd__a211o_1 abstract view
.subckt sky130_fd_sc_hd__a211o_1 A1 A2 B1 C1 VGND VNB VPB VPWR X
.ends

* Black-box entry subcircuit for sky130_fd_sc_hd__xnor2_1 abstract view
.subckt sky130_fd_sc_hd__xnor2_1 A B VGND VNB VPB VPWR Y
.ends

* Black-box entry subcircuit for sky130_fd_sc_hd__dfrtp_4 abstract view
.subckt sky130_fd_sc_hd__dfrtp_4 CLK D RESET_B VGND VNB VPB VPWR Q
.ends

* Black-box entry subcircuit for sky130_fd_sc_hd__decap_3 abstract view
.subckt sky130_fd_sc_hd__decap_3 VGND VNB VPB VPWR
.ends

* Black-box entry subcircuit for sky130_fd_sc_hd__dfrtp_1 abstract view
.subckt sky130_fd_sc_hd__dfrtp_1 CLK D RESET_B VGND VNB VPB VPWR Q
.ends

* Black-box entry subcircuit for sky130_fd_sc_hd__dfxtp_1 abstract view
.subckt sky130_fd_sc_hd__dfxtp_1 CLK D VGND VNB VPB VPWR Q
.ends

* Black-box entry subcircuit for sky130_fd_sc_hd__nand2_1 abstract view
.subckt sky130_fd_sc_hd__nand2_1 A B VGND VNB VPB VPWR Y
.ends

* Black-box entry subcircuit for sky130_fd_sc_hd__inv_2 abstract view
.subckt sky130_fd_sc_hd__inv_2 A VGND VNB VPB VPWR Y
.ends

* Black-box entry subcircuit for sky130_fd_sc_hd__a21bo_1 abstract view
.subckt sky130_fd_sc_hd__a21bo_1 A1 A2 B1_N VGND VNB VPB VPWR X
.ends

* Black-box entry subcircuit for sky130_fd_sc_hd__a31o_1 abstract view
.subckt sky130_fd_sc_hd__a31o_1 A1 A2 A3 B1 VGND VNB VPB VPWR X
.ends

* Black-box entry subcircuit for sky130_fd_sc_hd__a21oi_1 abstract view
.subckt sky130_fd_sc_hd__a21oi_1 A1 A2 B1 VGND VNB VPB VPWR Y
.ends

* Black-box entry subcircuit for sky130_fd_sc_hd__dlygate4sd3_1 abstract view
.subckt sky130_fd_sc_hd__dlygate4sd3_1 A VGND VNB VPB VPWR X
.ends

* Black-box entry subcircuit for sky130_fd_sc_hd__o211a_1 abstract view
.subckt sky130_fd_sc_hd__o211a_1 A1 A2 B1 C1 VGND VNB VPB VPWR X
.ends

* Black-box entry subcircuit for sky130_fd_sc_hd__diode_2 abstract view
.subckt sky130_fd_sc_hd__diode_2 DIODE VGND VNB VPB VPWR
.ends

* Black-box entry subcircuit for sky130_fd_sc_hd__nand2_2 abstract view
.subckt sky130_fd_sc_hd__nand2_2 A B VGND VNB VPB VPWR Y
.ends

* Black-box entry subcircuit for sky130_fd_sc_hd__or4_1 abstract view
.subckt sky130_fd_sc_hd__or4_1 A B C D VGND VNB VPB VPWR X
.ends

* Black-box entry subcircuit for sky130_fd_sc_hd__buf_2 abstract view
.subckt sky130_fd_sc_hd__buf_2 A VGND VNB VPB VPWR X
.ends

* Black-box entry subcircuit for sky130_fd_sc_hd__and3b_1 abstract view
.subckt sky130_fd_sc_hd__and3b_1 A_N B C VGND VNB VPB VPWR X
.ends

* Black-box entry subcircuit for sky130_fd_sc_hd__a32o_1 abstract view
.subckt sky130_fd_sc_hd__a32o_1 A1 A2 A3 B1 B2 VGND VNB VPB VPWR X
.ends

* Black-box entry subcircuit for sky130_fd_sc_hd__clkbuf_16 abstract view
.subckt sky130_fd_sc_hd__clkbuf_16 A VGND VNB VPB VPWR X
.ends

* Black-box entry subcircuit for sky130_fd_sc_hd__a221oi_1 abstract view
.subckt sky130_fd_sc_hd__a221oi_1 A1 A2 B1 B2 C1 VGND VNB VPB VPWR Y
.ends

* Black-box entry subcircuit for sky130_fd_sc_hd__o221ai_1 abstract view
.subckt sky130_fd_sc_hd__o221ai_1 A1 A2 B1 B2 C1 VGND VNB VPB VPWR Y
.ends

* Black-box entry subcircuit for sky130_fd_sc_hd__a21boi_1 abstract view
.subckt sky130_fd_sc_hd__a21boi_1 A1 A2 B1_N VGND VNB VPB VPWR Y
.ends

* Black-box entry subcircuit for sky130_fd_sc_hd__dfrtp_2 abstract view
.subckt sky130_fd_sc_hd__dfrtp_2 CLK D RESET_B VGND VNB VPB VPWR Q
.ends

* Black-box entry subcircuit for sky130_fd_sc_hd__o21ai_2 abstract view
.subckt sky130_fd_sc_hd__o21ai_2 A1 A2 B1 VGND VNB VPB VPWR Y
.ends

* Black-box entry subcircuit for sky130_fd_sc_hd__nor3_2 abstract view
.subckt sky130_fd_sc_hd__nor3_2 A B C VGND VNB VPB VPWR Y
.ends

* Black-box entry subcircuit for sky130_fd_sc_hd__xnor2_2 abstract view
.subckt sky130_fd_sc_hd__xnor2_2 A B VGND VNB VPB VPWR Y
.ends

* Black-box entry subcircuit for sky130_fd_sc_hd__o22a_1 abstract view
.subckt sky130_fd_sc_hd__o22a_1 A1 A2 B1 B2 VGND VNB VPB VPWR X
.ends

* Black-box entry subcircuit for sky130_fd_sc_hd__xor2_1 abstract view
.subckt sky130_fd_sc_hd__xor2_1 A B VGND VNB VPB VPWR X
.ends

* Black-box entry subcircuit for sky130_fd_sc_hd__or3b_4 abstract view
.subckt sky130_fd_sc_hd__or3b_4 A B C_N VGND VNB VPB VPWR X
.ends

* Black-box entry subcircuit for sky130_fd_sc_hd__decap_8 abstract view
.subckt sky130_fd_sc_hd__decap_8 VGND VNB VPB VPWR
.ends

* Black-box entry subcircuit for sky130_fd_sc_hd__clkbuf_4 abstract view
.subckt sky130_fd_sc_hd__clkbuf_4 A VGND VNB VPB VPWR X
.ends

* Black-box entry subcircuit for sky130_fd_sc_hd__or4_2 abstract view
.subckt sky130_fd_sc_hd__or4_2 A B C D VGND VNB VPB VPWR X
.ends

* Black-box entry subcircuit for sky130_fd_sc_hd__and3_1 abstract view
.subckt sky130_fd_sc_hd__and3_1 A B C VGND VNB VPB VPWR X
.ends

* Black-box entry subcircuit for sky130_ef_sc_hd__decap_12 abstract view
.subckt sky130_ef_sc_hd__decap_12 VPWR VGND VPB VNB
.ends

* Black-box entry subcircuit for sky130_fd_sc_hd__o221a_1 abstract view
.subckt sky130_fd_sc_hd__o221a_1 A1 A2 B1 B2 C1 VGND VNB VPB VPWR X
.ends

* Black-box entry subcircuit for sky130_fd_sc_hd__xor2_2 abstract view
.subckt sky130_fd_sc_hd__xor2_2 A B VGND VNB VPB VPWR X
.ends

* Black-box entry subcircuit for sky130_fd_sc_hd__or2b_1 abstract view
.subckt sky130_fd_sc_hd__or2b_1 A B_N VGND VNB VPB VPWR X
.ends

* Black-box entry subcircuit for sky130_fd_sc_hd__buf_1 abstract view
.subckt sky130_fd_sc_hd__buf_1 A VGND VNB VPB VPWR X
.ends

* Black-box entry subcircuit for sky130_fd_sc_hd__nand3_4 abstract view
.subckt sky130_fd_sc_hd__nand3_4 A B C VGND VNB VPB VPWR Y
.ends

* Black-box entry subcircuit for sky130_fd_sc_hd__and3_2 abstract view
.subckt sky130_fd_sc_hd__and3_2 A B C VGND VNB VPB VPWR X
.ends

* Black-box entry subcircuit for sky130_fd_sc_hd__or4b_1 abstract view
.subckt sky130_fd_sc_hd__or4b_1 A B C D_N VGND VNB VPB VPWR X
.ends

* Black-box entry subcircuit for sky130_fd_sc_hd__o21ba_1 abstract view
.subckt sky130_fd_sc_hd__o21ba_1 A1 A2 B1_N VGND VNB VPB VPWR X
.ends

* Black-box entry subcircuit for sky130_fd_sc_hd__o31ai_4 abstract view
.subckt sky130_fd_sc_hd__o31ai_4 A1 A2 A3 B1 VGND VNB VPB VPWR Y
.ends

* Black-box entry subcircuit for sky130_fd_sc_hd__a21boi_2 abstract view
.subckt sky130_fd_sc_hd__a21boi_2 A1 A2 B1_N VGND VNB VPB VPWR Y
.ends

* Black-box entry subcircuit for sky130_fd_sc_hd__nor2_4 abstract view
.subckt sky130_fd_sc_hd__nor2_4 A B VGND VNB VPB VPWR Y
.ends

* Black-box entry subcircuit for sky130_fd_sc_hd__o21bai_1 abstract view
.subckt sky130_fd_sc_hd__o21bai_1 A1 A2 B1_N VGND VNB VPB VPWR Y
.ends

* Black-box entry subcircuit for sky130_fd_sc_hd__o31a_1 abstract view
.subckt sky130_fd_sc_hd__o31a_1 A1 A2 A3 B1 VGND VNB VPB VPWR X
.ends

* Black-box entry subcircuit for sky130_fd_sc_hd__mux2_1 abstract view
.subckt sky130_fd_sc_hd__mux2_1 A0 A1 S VGND VNB VPB VPWR X
.ends

* Black-box entry subcircuit for sky130_fd_sc_hd__nand3_1 abstract view
.subckt sky130_fd_sc_hd__nand3_1 A B C VGND VNB VPB VPWR Y
.ends

* Black-box entry subcircuit for sky130_fd_sc_hd__a31o_2 abstract view
.subckt sky130_fd_sc_hd__a31o_2 A1 A2 A3 B1 VGND VNB VPB VPWR X
.ends

* Black-box entry subcircuit for sky130_fd_sc_hd__a221o_1 abstract view
.subckt sky130_fd_sc_hd__a221o_1 A1 A2 B1 B2 C1 VGND VNB VPB VPWR X
.ends

* Black-box entry subcircuit for sky130_fd_sc_hd__dfxtp_2 abstract view
.subckt sky130_fd_sc_hd__dfxtp_2 CLK D VGND VNB VPB VPWR Q
.ends

* Black-box entry subcircuit for sky130_fd_sc_hd__a2111o_1 abstract view
.subckt sky130_fd_sc_hd__a2111o_1 A1 A2 B1 C1 D1 VGND VNB VPB VPWR X
.ends

* Black-box entry subcircuit for sky130_fd_sc_hd__or3b_1 abstract view
.subckt sky130_fd_sc_hd__or3b_1 A B C_N VGND VNB VPB VPWR X
.ends

* Black-box entry subcircuit for sky130_fd_sc_hd__o32a_1 abstract view
.subckt sky130_fd_sc_hd__o32a_1 A1 A2 A3 B1 B2 VGND VNB VPB VPWR X
.ends

* Black-box entry subcircuit for sky130_fd_sc_hd__or4bb_1 abstract view
.subckt sky130_fd_sc_hd__or4bb_1 A B C_N D_N VGND VNB VPB VPWR X
.ends

* Black-box entry subcircuit for sky130_fd_sc_hd__dlymetal6s2s_1 abstract view
.subckt sky130_fd_sc_hd__dlymetal6s2s_1 A VGND VNB VPB VPWR X
.ends

* Black-box entry subcircuit for sky130_fd_sc_hd__nand4_1 abstract view
.subckt sky130_fd_sc_hd__nand4_1 A B C D VGND VNB VPB VPWR Y
.ends

* Black-box entry subcircuit for sky130_fd_sc_hd__and2b_1 abstract view
.subckt sky130_fd_sc_hd__and2b_1 A_N B VGND VNB VPB VPWR X
.ends

* Black-box entry subcircuit for sky130_fd_sc_hd__a2bb2o_1 abstract view
.subckt sky130_fd_sc_hd__a2bb2o_1 A1_N A2_N B1 B2 VGND VNB VPB VPWR X
.ends

* Black-box entry subcircuit for sky130_fd_sc_hd__a211oi_1 abstract view
.subckt sky130_fd_sc_hd__a211oi_1 A1 A2 B1 C1 VGND VNB VPB VPWR Y
.ends

* Black-box entry subcircuit for sky130_fd_sc_hd__o211ai_2 abstract view
.subckt sky130_fd_sc_hd__o211ai_2 A1 A2 B1 C1 VGND VNB VPB VPWR Y
.ends

* Black-box entry subcircuit for sky130_fd_sc_hd__and4b_2 abstract view
.subckt sky130_fd_sc_hd__and4b_2 A_N B C D VGND VNB VPB VPWR X
.ends

* Black-box entry subcircuit for sky130_fd_sc_hd__or3_1 abstract view
.subckt sky130_fd_sc_hd__or3_1 A B C VGND VNB VPB VPWR X
.ends

* Black-box entry subcircuit for sky130_fd_sc_hd__and4b_1 abstract view
.subckt sky130_fd_sc_hd__and4b_1 A_N B C D VGND VNB VPB VPWR X
.ends

* Black-box entry subcircuit for sky130_fd_sc_hd__and4_1 abstract view
.subckt sky130_fd_sc_hd__and4_1 A B C D VGND VNB VPB VPWR X
.ends

* Black-box entry subcircuit for sky130_fd_sc_hd__a31oi_2 abstract view
.subckt sky130_fd_sc_hd__a31oi_2 A1 A2 A3 B1 VGND VNB VPB VPWR Y
.ends

* Black-box entry subcircuit for sky130_fd_sc_hd__buf_4 abstract view
.subckt sky130_fd_sc_hd__buf_4 A VGND VNB VPB VPWR X
.ends

* Black-box entry subcircuit for sky130_fd_sc_hd__a2bb2o_2 abstract view
.subckt sky130_fd_sc_hd__a2bb2o_2 A1_N A2_N B1 B2 VGND VNB VPB VPWR X
.ends

* Black-box entry subcircuit for sky130_fd_sc_hd__nor3_1 abstract view
.subckt sky130_fd_sc_hd__nor3_1 A B C VGND VNB VPB VPWR Y
.ends

* Black-box entry subcircuit for sky130_fd_sc_hd__or2_4 abstract view
.subckt sky130_fd_sc_hd__or2_4 A B VGND VNB VPB VPWR X
.ends

* Black-box entry subcircuit for sky130_fd_sc_hd__o22ai_1 abstract view
.subckt sky130_fd_sc_hd__o22ai_1 A1 A2 B1 B2 VGND VNB VPB VPWR Y
.ends

* Black-box entry subcircuit for sky130_fd_sc_hd__and4_2 abstract view
.subckt sky130_fd_sc_hd__and4_2 A B C D VGND VNB VPB VPWR X
.ends

* Black-box entry subcircuit for sky130_fd_sc_hd__and4bb_1 abstract view
.subckt sky130_fd_sc_hd__and4bb_1 A_N B_N C D VGND VNB VPB VPWR X
.ends

* Black-box entry subcircuit for sky130_fd_sc_hd__dfxtp_4 abstract view
.subckt sky130_fd_sc_hd__dfxtp_4 CLK D VGND VNB VPB VPWR Q
.ends

* Black-box entry subcircuit for sky130_fd_sc_hd__o2bb2a_1 abstract view
.subckt sky130_fd_sc_hd__o2bb2a_1 A1_N A2_N B1 B2 VGND VNB VPB VPWR X
.ends

* Black-box entry subcircuit for sky130_fd_sc_hd__a31oi_1 abstract view
.subckt sky130_fd_sc_hd__a31oi_1 A1 A2 A3 B1 VGND VNB VPB VPWR Y
.ends

* Black-box entry subcircuit for sky130_fd_sc_hd__a22oi_1 abstract view
.subckt sky130_fd_sc_hd__a22oi_1 A1 A2 B1 B2 VGND VNB VPB VPWR Y
.ends

* Black-box entry subcircuit for sky130_fd_sc_hd__nand2_4 abstract view
.subckt sky130_fd_sc_hd__nand2_4 A B VGND VNB VPB VPWR Y
.ends

* Black-box entry subcircuit for sky130_fd_sc_hd__o21bai_2 abstract view
.subckt sky130_fd_sc_hd__o21bai_2 A1 A2 B1_N VGND VNB VPB VPWR Y
.ends

* Black-box entry subcircuit for sky130_fd_sc_hd__or2b_2 abstract view
.subckt sky130_fd_sc_hd__or2b_2 A B_N VGND VNB VPB VPWR X
.ends

* Black-box entry subcircuit for sky130_fd_sc_hd__or3_2 abstract view
.subckt sky130_fd_sc_hd__or3_2 A B C VGND VNB VPB VPWR X
.ends

* Black-box entry subcircuit for sky130_fd_sc_hd__o22ai_4 abstract view
.subckt sky130_fd_sc_hd__o22ai_4 A1 A2 B1 B2 VGND VNB VPB VPWR Y
.ends

* Black-box entry subcircuit for sky130_fd_sc_hd__and3b_2 abstract view
.subckt sky130_fd_sc_hd__and3b_2 A_N B C VGND VNB VPB VPWR X
.ends

* Black-box entry subcircuit for sky130_fd_sc_hd__a22oi_2 abstract view
.subckt sky130_fd_sc_hd__a22oi_2 A1 A2 B1 B2 VGND VNB VPB VPWR Y
.ends

* Black-box entry subcircuit for sky130_fd_sc_hd__xnor2_4 abstract view
.subckt sky130_fd_sc_hd__xnor2_4 A B VGND VNB VPB VPWR Y
.ends

* Black-box entry subcircuit for sky130_fd_sc_hd__o31ai_1 abstract view
.subckt sky130_fd_sc_hd__o31ai_1 A1 A2 A3 B1 VGND VNB VPB VPWR Y
.ends

* Black-box entry subcircuit for sky130_fd_sc_hd__a32o_2 abstract view
.subckt sky130_fd_sc_hd__a32o_2 A1 A2 A3 B1 B2 VGND VNB VPB VPWR X
.ends

* Black-box entry subcircuit for sky130_fd_sc_hd__a311o_1 abstract view
.subckt sky130_fd_sc_hd__a311o_1 A1 A2 A3 B1 C1 VGND VNB VPB VPWR X
.ends

* Black-box entry subcircuit for sky130_fd_sc_hd__a21o_2 abstract view
.subckt sky130_fd_sc_hd__a21o_2 A1 A2 B1 VGND VNB VPB VPWR X
.ends

* Black-box entry subcircuit for sky130_fd_sc_hd__o221a_2 abstract view
.subckt sky130_fd_sc_hd__o221a_2 A1 A2 B1 B2 C1 VGND VNB VPB VPWR X
.ends

* Black-box entry subcircuit for sky130_fd_sc_hd__a41o_1 abstract view
.subckt sky130_fd_sc_hd__a41o_1 A1 A2 A3 A4 B1 VGND VNB VPB VPWR X
.ends

* Black-box entry subcircuit for sky130_fd_sc_hd__a22oi_4 abstract view
.subckt sky130_fd_sc_hd__a22oi_4 A1 A2 B1 B2 VGND VNB VPB VPWR Y
.ends

* Black-box entry subcircuit for sky130_fd_sc_hd__o22ai_2 abstract view
.subckt sky130_fd_sc_hd__o22ai_2 A1 A2 B1 B2 VGND VNB VPB VPWR Y
.ends

* Black-box entry subcircuit for sky130_fd_sc_hd__and2_2 abstract view
.subckt sky130_fd_sc_hd__and2_2 A B VGND VNB VPB VPWR X
.ends

* Black-box entry subcircuit for sky130_fd_sc_hd__nor4_1 abstract view
.subckt sky130_fd_sc_hd__nor4_1 A B C D VGND VNB VPB VPWR Y
.ends

* Black-box entry subcircuit for sky130_fd_sc_hd__nand3_2 abstract view
.subckt sky130_fd_sc_hd__nand3_2 A B C VGND VNB VPB VPWR Y
.ends

* Black-box entry subcircuit for sky130_fd_sc_hd__mux4_1 abstract view
.subckt sky130_fd_sc_hd__mux4_1 A0 A1 A2 A3 S0 S1 VGND VNB VPB VPWR X
.ends

* Black-box entry subcircuit for sky130_fd_sc_hd__o211ai_1 abstract view
.subckt sky130_fd_sc_hd__o211ai_1 A1 A2 B1 C1 VGND VNB VPB VPWR Y
.ends

* Black-box entry subcircuit for sky130_fd_sc_hd__or2_2 abstract view
.subckt sky130_fd_sc_hd__or2_2 A B VGND VNB VPB VPWR X
.ends

* Black-box entry subcircuit for sky130_fd_sc_hd__conb_1 abstract view
.subckt sky130_fd_sc_hd__conb_1 VGND VNB VPB VPWR HI LO
.ends

* Black-box entry subcircuit for sky130_fd_sc_hd__a31oi_4 abstract view
.subckt sky130_fd_sc_hd__a31oi_4 A1 A2 A3 B1 VGND VNB VPB VPWR Y
.ends

* Black-box entry subcircuit for sky130_fd_sc_hd__or4_4 abstract view
.subckt sky130_fd_sc_hd__or4_4 A B C D VGND VNB VPB VPWR X
.ends

* Black-box entry subcircuit for sky130_fd_sc_hd__a21oi_4 abstract view
.subckt sky130_fd_sc_hd__a21oi_4 A1 A2 B1 VGND VNB VPB VPWR Y
.ends

* Black-box entry subcircuit for sky130_fd_sc_hd__o2111a_1 abstract view
.subckt sky130_fd_sc_hd__o2111a_1 A1 A2 B1 C1 D1 VGND VNB VPB VPWR X
.ends

* Black-box entry subcircuit for sky130_fd_sc_hd__nand3b_1 abstract view
.subckt sky130_fd_sc_hd__nand3b_1 A_N B C VGND VNB VPB VPWR Y
.ends

.subckt uart_top S_AXI_ACLK S_AXI_ARADDR[0] S_AXI_ARADDR[10] S_AXI_ARADDR[11] S_AXI_ARADDR[12]
+ S_AXI_ARADDR[13] S_AXI_ARADDR[14] S_AXI_ARADDR[15] S_AXI_ARADDR[16] S_AXI_ARADDR[17]
+ S_AXI_ARADDR[18] S_AXI_ARADDR[19] S_AXI_ARADDR[1] S_AXI_ARADDR[20] S_AXI_ARADDR[21]
+ S_AXI_ARADDR[22] S_AXI_ARADDR[23] S_AXI_ARADDR[24] S_AXI_ARADDR[25] S_AXI_ARADDR[26]
+ S_AXI_ARADDR[27] S_AXI_ARADDR[28] S_AXI_ARADDR[29] S_AXI_ARADDR[2] S_AXI_ARADDR[30]
+ S_AXI_ARADDR[31] S_AXI_ARADDR[3] S_AXI_ARADDR[4] S_AXI_ARADDR[5] S_AXI_ARADDR[6]
+ S_AXI_ARADDR[7] S_AXI_ARADDR[8] S_AXI_ARADDR[9] S_AXI_ARESETN S_AXI_ARREADY S_AXI_ARVALID
+ S_AXI_AWADDR[0] S_AXI_AWADDR[10] S_AXI_AWADDR[11] S_AXI_AWADDR[12] S_AXI_AWADDR[13]
+ S_AXI_AWADDR[14] S_AXI_AWADDR[15] S_AXI_AWADDR[16] S_AXI_AWADDR[17] S_AXI_AWADDR[18]
+ S_AXI_AWADDR[19] S_AXI_AWADDR[1] S_AXI_AWADDR[20] S_AXI_AWADDR[21] S_AXI_AWADDR[22]
+ S_AXI_AWADDR[23] S_AXI_AWADDR[24] S_AXI_AWADDR[25] S_AXI_AWADDR[26] S_AXI_AWADDR[27]
+ S_AXI_AWADDR[28] S_AXI_AWADDR[29] S_AXI_AWADDR[2] S_AXI_AWADDR[30] S_AXI_AWADDR[31]
+ S_AXI_AWADDR[3] S_AXI_AWADDR[4] S_AXI_AWADDR[5] S_AXI_AWADDR[6] S_AXI_AWADDR[7]
+ S_AXI_AWADDR[8] S_AXI_AWADDR[9] S_AXI_AWREADY S_AXI_AWVALID S_AXI_BREADY S_AXI_BRESP[0]
+ S_AXI_BRESP[1] S_AXI_BVALID S_AXI_RDATA[0] S_AXI_RDATA[10] S_AXI_RDATA[11] S_AXI_RDATA[12]
+ S_AXI_RDATA[13] S_AXI_RDATA[14] S_AXI_RDATA[15] S_AXI_RDATA[16] S_AXI_RDATA[17]
+ S_AXI_RDATA[18] S_AXI_RDATA[19] S_AXI_RDATA[1] S_AXI_RDATA[20] S_AXI_RDATA[21] S_AXI_RDATA[22]
+ S_AXI_RDATA[23] S_AXI_RDATA[24] S_AXI_RDATA[25] S_AXI_RDATA[26] S_AXI_RDATA[27]
+ S_AXI_RDATA[28] S_AXI_RDATA[29] S_AXI_RDATA[2] S_AXI_RDATA[30] S_AXI_RDATA[31] S_AXI_RDATA[3]
+ S_AXI_RDATA[4] S_AXI_RDATA[5] S_AXI_RDATA[6] S_AXI_RDATA[7] S_AXI_RDATA[8] S_AXI_RDATA[9]
+ S_AXI_RREADY S_AXI_RRESP[0] S_AXI_RRESP[1] S_AXI_RVALID S_AXI_WDATA[0] S_AXI_WDATA[10]
+ S_AXI_WDATA[11] S_AXI_WDATA[12] S_AXI_WDATA[13] S_AXI_WDATA[14] S_AXI_WDATA[15]
+ S_AXI_WDATA[16] S_AXI_WDATA[17] S_AXI_WDATA[18] S_AXI_WDATA[19] S_AXI_WDATA[1] S_AXI_WDATA[20]
+ S_AXI_WDATA[21] S_AXI_WDATA[22] S_AXI_WDATA[23] S_AXI_WDATA[24] S_AXI_WDATA[25]
+ S_AXI_WDATA[26] S_AXI_WDATA[27] S_AXI_WDATA[28] S_AXI_WDATA[29] S_AXI_WDATA[2] S_AXI_WDATA[30]
+ S_AXI_WDATA[31] S_AXI_WDATA[3] S_AXI_WDATA[4] S_AXI_WDATA[5] S_AXI_WDATA[6] S_AXI_WDATA[7]
+ S_AXI_WDATA[8] S_AXI_WDATA[9] S_AXI_WREADY S_AXI_WSTRB[0] S_AXI_WSTRB[1] S_AXI_WSTRB[2]
+ S_AXI_WSTRB[3] S_AXI_WVALID VGND VPWR uart_rx_i uart_tx_o
X_3155_ _1276_ VGND VGND VPWR VPWR _0185_ sky130_fd_sc_hd__clkbuf_1
X_2037_ _1700_ _1711_ VGND VGND VPWR VPWR _1712_ sky130_fd_sc_hd__and2_1
X_2106_ net329 _0324_ VGND VGND VPWR VPWR _0325_ sky130_fd_sc_hd__or2_1
X_3086_ RX.baud_cnt\[29\] _1230_ VGND VGND VPWR VPWR _1232_ sky130_fd_sc_hd__or2_1
XTAP_177 VGND VPWR sky130_fd_sc_hd__tapvpwrvgnd_1
XTAP_188 VGND VPWR sky130_fd_sc_hd__tapvpwrvgnd_1
XTAP_199 VGND VPWR sky130_fd_sc_hd__tapvpwrvgnd_1
X_2939_ _1103_ _1115_ _1108_ VGND VGND VPWR VPWR _1116_ sky130_fd_sc_hd__o21ai_1
XFILLER_0_17_222 VGND VGND VPWR VPWR sky130_fd_sc_hd__fill_2
XFILLER_0_32_269 VGND VGND VPWR VPWR sky130_fd_sc_hd__fill_1
XFILLER_0_23_29 VGND VGND VPWR VPWR sky130_fd_sc_hd__decap_4
XFILLER_0_3_39 VGND VGND VPWR VPWR sky130_fd_sc_hd__decap_6
X_2724_ RX.baud_cnt\[17\] _0414_ _0416_ RX.baud_cnt\[18\] VGND VGND VPWR VPWR _0901_
+ sky130_fd_sc_hd__a22o_1
X_2655_ TX.baud_counter\[13\] _0805_ _0804_ VGND VGND VPWR VPWR _0844_ sky130_fd_sc_hd__o21ai_1
X_3207_ net77 _1305_ _1306_ VGND VGND VPWR VPWR _0207_ sky130_fd_sc_hd__o21a_1
X_2586_ _0722_ _0774_ VGND VGND VPWR VPWR _0775_ sky130_fd_sc_hd__nor2_2
Xfanout149 net163 VGND VGND VPWR VPWR net149 sky130_fd_sc_hd__clkbuf_2
X_3138_ net207 VGND VGND VPWR VPWR _1268_ sky130_fd_sc_hd__clkbuf_1
X_3069_ _0895_ _1217_ RX.baud_cnt\[24\] VGND VGND VPWR VPWR _1220_ sky130_fd_sc_hd__a21o_1
XFILLER_0_20_228 VGND VGND VPWR VPWR sky130_fd_sc_hd__fill_1
XFILLER_0_18_29 VGND VGND VPWR VPWR sky130_fd_sc_hd__fill_1
XFILLER_0_34_39 VGND VGND VPWR VPWR sky130_fd_sc_hd__fill_1
XFILLER_0_28_306 VGND VGND VPWR VPWR sky130_fd_sc_hd__fill_2
XFILLER_0_55_169 VGND VGND VPWR VPWR sky130_fd_sc_hd__fill_1
XFILLER_0_51_320 VGND VGND VPWR VPWR sky130_fd_sc_hd__fill_1
X_2440_ _0624_ _0628_ VGND VGND VPWR VPWR _0629_ sky130_fd_sc_hd__nor2_1
XFILLER_0_11_228 VGND VGND VPWR VPWR sky130_fd_sc_hd__fill_1
X_2371_ _0548_ _0550_ _0554_ _0559_ VGND VGND VPWR VPWR _0560_ sky130_fd_sc_hd__a211o_1
XFILLER_0_34_309 VGND VGND VPWR VPWR sky130_fd_sc_hd__fill_2
X_2707_ net270 _0884_ VGND VGND VPWR VPWR _0889_ sky130_fd_sc_hd__or2_1
X_2569_ RX.uart_cpb\[31\] _1639_ VGND VGND VPWR VPWR _0758_ sky130_fd_sc_hd__xnor2_1
X_3687_ clknet_leaf_20_S_AXI_ACLK _0252_ net148 VGND VGND VPWR VPWR TX.baud_counter\[18\]
+ sky130_fd_sc_hd__dfrtp_4
X_2638_ TX.baud_counter\[5\] _0823_ VGND VGND VPWR VPWR _0827_ sky130_fd_sc_hd__or2_1
XFILLER_0_10_250 VGND VGND VPWR VPWR sky130_fd_sc_hd__fill_2
XFILLER_0_4_82 VGND VGND VPWR VPWR sky130_fd_sc_hd__fill_2
XFILLER_0_25_309 VGND VGND VPWR VPWR sky130_fd_sc_hd__fill_1
XFILLER_0_0_29 VGND VGND VPWR VPWR sky130_fd_sc_hd__decap_3
X_3610_ clknet_leaf_9_S_AXI_ACLK _0175_ net161 VGND VGND VPWR VPWR RX.rx_shifter\[8\]
+ sky130_fd_sc_hd__dfrtp_1
X_1871_ TX.uart_tdr\[16\] _1566_ _1567_ RX.uart_stp\[16\] VGND VGND VPWR VPWR _1589_
+ sky130_fd_sc_hd__a22o_1
X_1940_ TX.uart_tdr\[31\] _1506_ _1508_ RX.uart_stp\[31\] VGND VGND VPWR VPWR _1643_
+ sky130_fd_sc_hd__a22o_1
XFILLER_0_28_158 VGND VGND VPWR VPWR sky130_fd_sc_hd__fill_2
X_3541_ clknet_leaf_1_S_AXI_ACLK _0106_ VGND VGND VPWR VPWR TX.uart_tdr\[20\] sky130_fd_sc_hd__dfxtp_1
X_3472_ clknet_leaf_0_S_AXI_ACLK _0037_ VGND VGND VPWR VPWR net132 sky130_fd_sc_hd__dfxtp_1
XFILLER_0_36_191 VGND VGND VPWR VPWR sky130_fd_sc_hd__fill_2
XFILLER_0_3_269 VGND VGND VPWR VPWR sky130_fd_sc_hd__fill_2
XFILLER_0_10_52 VGND VGND VPWR VPWR sky130_fd_sc_hd__fill_1
XFILLER_0_10_85 VGND VGND VPWR VPWR sky130_fd_sc_hd__fill_1
X_2423_ _0609_ _0610_ _0611_ VGND VGND VPWR VPWR _0612_ sky130_fd_sc_hd__o21a_1
X_2285_ net224 _0484_ VGND VGND VPWR VPWR _0488_ sky130_fd_sc_hd__or2_1
X_2354_ RX.uart_cpb\[15\] RX.uart_cpb\[16\] VGND VGND VPWR VPWR _0543_ sky130_fd_sc_hd__xnor2_1
XFILLER_0_19_72 VGND VGND VPWR VPWR sky130_fd_sc_hd__fill_1
XFILLER_0_34_117 VGND VGND VPWR VPWR sky130_fd_sc_hd__decap_6
XFILLER_0_25_128 VGND VGND VPWR VPWR sky130_fd_sc_hd__fill_1
X_2070_ _0300_ _0290_ VGND VGND VPWR VPWR _0301_ sky130_fd_sc_hd__nand2_1
X_2972_ _1058_ _1148_ VGND VGND VPWR VPWR _1149_ sky130_fd_sc_hd__and2_1
XFILLER_0_56_253 VGND VGND VPWR VPWR sky130_fd_sc_hd__fill_1
X_1785_ net146 VGND VGND VPWR VPWR _1519_ sky130_fd_sc_hd__inv_2
X_1923_ uart_rdr\[27\] _1513_ _1494_ VGND VGND VPWR VPWR _1630_ sky130_fd_sc_hd__a21bo_1
X_1854_ uart_rdr\[12\] _1538_ _1550_ VGND VGND VPWR VPWR _1576_ sky130_fd_sc_hd__a21bo_1
XFILLER_0_16_139 VGND VGND VPWR VPWR sky130_fd_sc_hd__fill_1
X_3455_ clknet_leaf_5_S_AXI_ACLK _0020_ VGND VGND VPWR VPWR net114 sky130_fd_sc_hd__dfxtp_1
X_2406_ _0538_ _0541_ _0594_ _0546_ VGND VGND VPWR VPWR _0595_ sky130_fd_sc_hd__a31o_1
X_3524_ clknet_leaf_12_S_AXI_ACLK _0089_ VGND VGND VPWR VPWR TX.data_latch_next\[1\]
+ sky130_fd_sc_hd__dfxtp_1
X_3386_ TX.baud_counter\[28\] _1429_ _1352_ VGND VGND VPWR VPWR _1431_ sky130_fd_sc_hd__a21oi_1
X_2268_ _0468_ _0472_ _0470_ TX.bit_index\[2\] VGND VGND VPWR VPWR _0477_ sky130_fd_sc_hd__a31o_1
X_2337_ _0524_ _0525_ VGND VGND VPWR VPWR _0526_ sky130_fd_sc_hd__and2_1
X_2199_ TX.baud_counter\[15\] _0406_ VGND VGND VPWR VPWR _0410_ sky130_fd_sc_hd__or2_1
XFILLER_0_47_264 VGND VGND VPWR VPWR sky130_fd_sc_hd__fill_1
Xhold41 RX.rx_shifter\[13\] VGND VGND VPWR VPWR net208 sky130_fd_sc_hd__dlygate4sd3_1
Xhold52 RX.rx_shifter\[30\] VGND VGND VPWR VPWR net219 sky130_fd_sc_hd__dlygate4sd3_1
Xhold30 TX.uart_tdr\[30\] VGND VGND VPWR VPWR net197 sky130_fd_sc_hd__dlygate4sd3_1
Xhold74 net141 VGND VGND VPWR VPWR net241 sky130_fd_sc_hd__dlygate4sd3_1
XFILLER_0_30_197 VGND VGND VPWR VPWR sky130_fd_sc_hd__decap_4
XFILLER_0_26_29 VGND VGND VPWR VPWR sky130_fd_sc_hd__fill_1
Xhold63 uart_cfg\[2\] VGND VGND VPWR VPWR net230 sky130_fd_sc_hd__dlygate4sd3_1
Xhold85 RX.uart_stp\[30\] VGND VGND VPWR VPWR net252 sky130_fd_sc_hd__dlygate4sd3_1
Xhold96 TX.baud_counter\[27\] VGND VGND VPWR VPWR net263 sky130_fd_sc_hd__dlygate4sd3_1
XTAP_348 VGND VPWR sky130_fd_sc_hd__tapvpwrvgnd_1
X_3240_ net75 _1318_ _1325_ _1322_ VGND VGND VPWR VPWR _0221_ sky130_fd_sc_hd__o211a_1
XTAP_337 VGND VPWR sky130_fd_sc_hd__tapvpwrvgnd_1
XTAP_326 VGND VPWR sky130_fd_sc_hd__tapvpwrvgnd_1
XTAP_315 VGND VPWR sky130_fd_sc_hd__tapvpwrvgnd_1
XTAP_304 VGND VPWR sky130_fd_sc_hd__tapvpwrvgnd_1
XANTENNA_5 net117 VGND VGND VPWR VPWR sky130_fd_sc_hd__diode_2
X_3171_ _1284_ VGND VGND VPWR VPWR _0193_ sky130_fd_sc_hd__clkbuf_1
XTAP_359 VGND VPWR sky130_fd_sc_hd__tapvpwrvgnd_1
X_2053_ net109 net102 VGND VGND VPWR VPWR _0288_ sky130_fd_sc_hd__nand2_2
X_2122_ TX.bit_index\[0\] VGND VGND VPWR VPWR _0333_ sky130_fd_sc_hd__inv_2
X_2955_ RX.baud_cnt\[28\] _0771_ VGND VGND VPWR VPWR _1132_ sky130_fd_sc_hd__nand2_1
XFILLER_0_29_242 VGND VGND VPWR VPWR sky130_fd_sc_hd__fill_1
X_1906_ uart_rdr\[23\] _1513_ _1590_ VGND VGND VPWR VPWR _1617_ sky130_fd_sc_hd__a21bo_1
X_1768_ _1498_ _1499_ _1500_ _1501_ VGND VGND VPWR VPWR _1502_ sky130_fd_sc_hd__or4_1
X_1837_ RX.uart_cpb\[9\] VGND VGND VPWR VPWR _1562_ sky130_fd_sc_hd__buf_2
X_3507_ clknet_leaf_15_S_AXI_ACLK _0072_ VGND VGND VPWR VPWR RX.uart_cpb\[0\] sky130_fd_sc_hd__dfxtp_1
X_2886_ RX.baud_cnt\[2\] _0810_ VGND VGND VPWR VPWR _1063_ sky130_fd_sc_hd__nand2_1
X_3438_ clknet_leaf_4_S_AXI_ACLK _0003_ VGND VGND VPWR VPWR TX.uart_tdr\[27\] sky130_fd_sc_hd__dfxtp_1
X_3369_ _1381_ _1418_ VGND VGND VPWR VPWR _1419_ sky130_fd_sc_hd__nor2_1
XFILLER_0_1_334 VGND VGND VPWR VPWR sky130_fd_sc_hd__fill_2
X_2740_ _0914_ _0915_ _0916_ VGND VGND VPWR VPWR _0917_ sky130_fd_sc_hd__and3b_1
X_2671_ _0782_ _0792_ _0858_ _0859_ _0787_ VGND VGND VPWR VPWR _0860_ sky130_fd_sc_hd__a32o_1
X_3223_ _1314_ VGND VGND VPWR VPWR _1315_ sky130_fd_sc_hd__clkbuf_2
XTAP_145 VGND VPWR sky130_fd_sc_hd__tapvpwrvgnd_1
XTAP_134 VGND VPWR sky130_fd_sc_hd__tapvpwrvgnd_1
XFILLER_0_1_345 VGND VGND VPWR VPWR sky130_fd_sc_hd__fill_1
XTAP_123 VGND VPWR sky130_fd_sc_hd__tapvpwrvgnd_1
XTAP_156 VGND VPWR sky130_fd_sc_hd__tapvpwrvgnd_1
XTAP_167 VGND VPWR sky130_fd_sc_hd__tapvpwrvgnd_1
XTAP_178 VGND VPWR sky130_fd_sc_hd__tapvpwrvgnd_1
XTAP_189 VGND VPWR sky130_fd_sc_hd__tapvpwrvgnd_1
X_3154_ net195 VGND VGND VPWR VPWR _1276_ sky130_fd_sc_hd__clkbuf_1
X_2036_ _1690_ RX.rx_shifter\[27\] _1695_ uart_rdr\[27\] VGND VGND VPWR VPWR _1711_
+ sky130_fd_sc_hd__a22o_1
X_2105_ _1479_ _0288_ VGND VGND VPWR VPWR _0324_ sky130_fd_sc_hd__nor2_2
XFILLER_0_27_94 VGND VGND VPWR VPWR sky130_fd_sc_hd__fill_1
Xclkbuf_leaf_21_S_AXI_ACLK clknet_1_0__leaf_S_AXI_ACLK VGND VGND VPWR VPWR clknet_leaf_21_S_AXI_ACLK
+ sky130_fd_sc_hd__clkbuf_16
X_3085_ _1158_ _1229_ _1231_ _1186_ RX.baud_cnt\[28\] VGND VGND VPWR VPWR _0160_ sky130_fd_sc_hd__a32o_1
XFILLER_0_32_204 VGND VGND VPWR VPWR sky130_fd_sc_hd__fill_1
X_2938_ _0897_ _0779_ _1106_ _1107_ _1104_ VGND VGND VPWR VPWR _1115_ sky130_fd_sc_hd__a221oi_1
X_2869_ _1032_ _1045_ _1040_ VGND VGND VPWR VPWR _1046_ sky130_fd_sc_hd__o21a_1
XFILLER_0_13_96 VGND VGND VPWR VPWR sky130_fd_sc_hd__fill_1
X_2723_ RX.baud_cnt\[19\] _0421_ _0354_ RX.baud_cnt\[20\] VGND VGND VPWR VPWR _0900_
+ sky130_fd_sc_hd__a22o_1
X_2585_ _0704_ _0714_ _0721_ VGND VGND VPWR VPWR _0774_ sky130_fd_sc_hd__a21oi_1
X_2654_ TX.baud_counter\[13\] _0805_ _0838_ _0841_ _0842_ VGND VGND VPWR VPWR _0843_
+ sky130_fd_sc_hd__o221ai_1
X_3137_ _1267_ VGND VGND VPWR VPWR _0176_ sky130_fd_sc_hd__clkbuf_1
X_3206_ _0408_ _1304_ _0295_ VGND VGND VPWR VPWR _1306_ sky130_fd_sc_hd__a21boi_1
X_2019_ _1699_ VGND VGND VPWR VPWR _0061_ sky130_fd_sc_hd__clkbuf_1
X_3068_ _1194_ _1217_ _1219_ _1218_ _0895_ VGND VGND VPWR VPWR _0155_ sky130_fd_sc_hd__a32o_1
XFILLER_0_45_351 VGND VGND VPWR VPWR sky130_fd_sc_hd__fill_2
XFILLER_0_9_275 VGND VGND VPWR VPWR sky130_fd_sc_hd__fill_2
XFILLER_0_13_270 VGND VGND VPWR VPWR sky130_fd_sc_hd__fill_2
Xhold160 TX.data_latch\[6\] VGND VGND VPWR VPWR net327 sky130_fd_sc_hd__dlygate4sd3_1
XFILLER_0_20_207 VGND VGND VPWR VPWR sky130_fd_sc_hd__decap_4
X_2370_ _0558_ VGND VGND VPWR VPWR _0559_ sky130_fd_sc_hd__inv_2
XFILLER_0_24_51 VGND VGND VPWR VPWR sky130_fd_sc_hd__decap_3
X_2706_ net80 _0883_ _0888_ _0502_ VGND VGND VPWR VPWR _0124_ sky130_fd_sc_hd__o211a_1
XFILLER_0_27_362 VGND VGND VPWR VPWR sky130_fd_sc_hd__fill_2
X_3686_ clknet_leaf_20_S_AXI_ACLK _0251_ net147 VGND VGND VPWR VPWR TX.baud_counter\[17\]
+ sky130_fd_sc_hd__dfrtp_2
XFILLER_0_49_81 VGND VGND VPWR VPWR sky130_fd_sc_hd__decap_4
X_2568_ _0744_ _0747_ _0756_ VGND VGND VPWR VPWR _0757_ sky130_fd_sc_hd__o21ai_2
X_2499_ _0680_ _0683_ _0687_ VGND VGND VPWR VPWR _0688_ sky130_fd_sc_hd__nor3_2
X_2637_ _0825_ _0617_ VGND VGND VPWR VPWR _0826_ sky130_fd_sc_hd__xnor2_2
X_1870_ _1571_ net274 _1561_ _1588_ VGND VGND VPWR VPWR _0023_ sky130_fd_sc_hd__o211a_1
X_3540_ clknet_leaf_0_S_AXI_ACLK _0105_ VGND VGND VPWR VPWR TX.uart_tdr\[19\] sky130_fd_sc_hd__dfxtp_1
XFILLER_0_9_28 VGND VGND VPWR VPWR sky130_fd_sc_hd__fill_1
X_3471_ clknet_leaf_1_S_AXI_ACLK _0036_ VGND VGND VPWR VPWR net131 sky130_fd_sc_hd__dfxtp_1
X_2353_ _0339_ _0541_ VGND VGND VPWR VPWR _0542_ sky130_fd_sc_hd__nand2_1
X_2422_ _0312_ _1541_ _0603_ _1545_ VGND VGND VPWR VPWR _0611_ sky130_fd_sc_hd__o22a_1
X_2284_ net78 _0483_ _0486_ _0487_ VGND VGND VPWR VPWR _0103_ sky130_fd_sc_hd__o211a_1
XFILLER_0_36_7 VGND VGND VPWR VPWR sky130_fd_sc_hd__decap_6
XFILLER_0_34_107 VGND VGND VPWR VPWR sky130_fd_sc_hd__fill_1
X_1999_ _1685_ VGND VGND VPWR VPWR _0055_ sky130_fd_sc_hd__clkbuf_1
X_3669_ clknet_leaf_19_S_AXI_ACLK _0234_ net151 VGND VGND VPWR VPWR TX.baud_counter\[0\]
+ sky130_fd_sc_hd__dfrtp_4
XFILLER_0_18_170 VGND VGND VPWR VPWR sky130_fd_sc_hd__fill_2
XFILLER_0_21_335 VGND VGND VPWR VPWR sky130_fd_sc_hd__fill_1
XFILLER_0_56_27 VGND VGND VPWR VPWR sky130_fd_sc_hd__fill_1
X_1922_ TX.uart_tdr\[27\] _1604_ _1605_ RX.uart_stp\[27\] VGND VGND VPWR VPWR _1629_
+ sky130_fd_sc_hd__a22o_1
X_2971_ RX.state\[1\] _1145_ _1146_ _1147_ VGND VGND VPWR VPWR _1148_ sky130_fd_sc_hd__a31o_1
X_1784_ _1516_ _1517_ VGND VGND VPWR VPWR _1518_ sky130_fd_sc_hd__nor2_2
X_1853_ TX.uart_tdr\[12\] _1566_ _1567_ RX.uart_stp\[12\] VGND VGND VPWR VPWR _1575_
+ sky130_fd_sc_hd__a22o_1
X_3523_ clknet_leaf_12_S_AXI_ACLK _0088_ VGND VGND VPWR VPWR TX.data_latch_next\[0\]
+ sky130_fd_sc_hd__dfxtp_1
XFILLER_0_24_195 VGND VGND VPWR VPWR sky130_fd_sc_hd__fill_1
XFILLER_0_24_162 VGND VGND VPWR VPWR sky130_fd_sc_hd__fill_1
XFILLER_0_16_107 VGND VGND VPWR VPWR sky130_fd_sc_hd__fill_2
X_3454_ clknet_leaf_8_S_AXI_ACLK _0019_ VGND VGND VPWR VPWR net113 sky130_fd_sc_hd__dfxtp_1
X_2405_ _0534_ _0537_ _0593_ VGND VGND VPWR VPWR _0594_ sky130_fd_sc_hd__a21bo_1
X_3385_ _1364_ _1428_ _1430_ _1403_ net263 VGND VGND VPWR VPWR _0261_ sky130_fd_sc_hd__a32o_1
X_2336_ RX.uart_cpb\[6\] RX.uart_cpb\[5\] VGND VGND VPWR VPWR _0525_ sky130_fd_sc_hd__xor2_1
XFILLER_0_46_93 VGND VGND VPWR VPWR sky130_fd_sc_hd__decap_3
X_2198_ _0408_ _0341_ VGND VGND VPWR VPWR _0409_ sky130_fd_sc_hd__xnor2_2
XFILLER_0_27_3 VGND VGND VPWR VPWR sky130_fd_sc_hd__fill_1
XFILLER_0_1_73 VGND VGND VPWR VPWR sky130_fd_sc_hd__fill_1
X_2267_ TX.state\[0\] _0468_ VGND VGND VPWR VPWR _0476_ sky130_fd_sc_hd__nand2_1
XFILLER_0_30_121 VGND VGND VPWR VPWR sky130_fd_sc_hd__decap_6
Xhold53 RX.rx_shifter\[19\] VGND VGND VPWR VPWR net220 sky130_fd_sc_hd__dlygate4sd3_1
Xhold42 RX.rx_shifter\[27\] VGND VGND VPWR VPWR net209 sky130_fd_sc_hd__dlygate4sd3_1
Xhold31 RX.rx_shifter\[15\] VGND VGND VPWR VPWR net198 sky130_fd_sc_hd__dlygate4sd3_1
Xhold75 TX.uart_tdr\[14\] VGND VGND VPWR VPWR net242 sky130_fd_sc_hd__dlygate4sd3_1
Xhold64 RX.rx_shifter\[28\] VGND VGND VPWR VPWR net231 sky130_fd_sc_hd__dlygate4sd3_1
Xhold86 RX.rx_shifter\[8\] VGND VGND VPWR VPWR net253 sky130_fd_sc_hd__dlygate4sd3_1
Xhold20 net110 VGND VGND VPWR VPWR net187 sky130_fd_sc_hd__dlygate4sd3_1
Xhold97 TX.baud_counter\[29\] VGND VGND VPWR VPWR net264 sky130_fd_sc_hd__dlygate4sd3_1
XANTENNA_6 net122 VGND VGND VPWR VPWR sky130_fd_sc_hd__diode_2
XFILLER_0_21_110 VGND VGND VPWR VPWR sky130_fd_sc_hd__fill_2
X_3170_ net217 VGND VGND VPWR VPWR _1284_ sky130_fd_sc_hd__clkbuf_1
XTAP_349 VGND VPWR sky130_fd_sc_hd__tapvpwrvgnd_1
XTAP_338 VGND VPWR sky130_fd_sc_hd__tapvpwrvgnd_1
XTAP_327 VGND VPWR sky130_fd_sc_hd__tapvpwrvgnd_1
XTAP_316 VGND VPWR sky130_fd_sc_hd__tapvpwrvgnd_1
XTAP_305 VGND VPWR sky130_fd_sc_hd__tapvpwrvgnd_1
Xclkbuf_leaf_11_S_AXI_ACLK clknet_1_1__leaf_S_AXI_ACLK VGND VGND VPWR VPWR clknet_leaf_11_S_AXI_ACLK
+ sky130_fd_sc_hd__clkbuf_16
X_2052_ _0286_ net57 _1473_ VGND VGND VPWR VPWR _0287_ sky130_fd_sc_hd__or3b_4
XFILLER_0_16_85 VGND VGND VPWR VPWR sky130_fd_sc_hd__decap_8
X_2121_ net99 _0323_ _0332_ _0321_ VGND VGND VPWR VPWR _0095_ sky130_fd_sc_hd__o211a_1
X_1905_ TX.uart_tdr\[23\] _1604_ _1605_ RX.uart_stp\[23\] VGND VGND VPWR VPWR _1616_
+ sky130_fd_sc_hd__a22o_1
X_2954_ RX.baud_cnt\[28\] _0771_ VGND VGND VPWR VPWR _1131_ sky130_fd_sc_hd__or2_1
XFILLER_0_29_287 VGND VGND VPWR VPWR sky130_fd_sc_hd__fill_2
XFILLER_0_29_232 VGND VGND VPWR VPWR sky130_fd_sc_hd__fill_2
X_2885_ _1060_ _1061_ VGND VGND VPWR VPWR _1062_ sky130_fd_sc_hd__nand2_1
X_3506_ clknet_leaf_6_S_AXI_ACLK _0071_ VGND VGND VPWR VPWR uart_rdr\[31\] sky130_fd_sc_hd__dfxtp_1
X_1836_ _1485_ VGND VGND VPWR VPWR _1561_ sky130_fd_sc_hd__clkbuf_4
X_1767_ net9 net8 net11 net10 VGND VGND VPWR VPWR _1501_ sky130_fd_sc_hd__or4_2
X_3437_ clknet_leaf_2_S_AXI_ACLK _0002_ VGND VGND VPWR VPWR TX.uart_tdr\[26\] sky130_fd_sc_hd__dfxtp_1
X_2319_ _0507_ VGND VGND VPWR VPWR _0508_ sky130_fd_sc_hd__inv_2
X_3299_ _1365_ _1366_ VGND VGND VPWR VPWR _1367_ sky130_fd_sc_hd__nor2_1
X_3368_ TX.baud_counter\[23\] TX.baud_counter\[22\] _1413_ VGND VGND VPWR VPWR _1418_
+ sky130_fd_sc_hd__and3_1
XFILLER_0_1_302 VPWR VGND VPWR VGND sky130_ef_sc_hd__decap_12
X_2670_ _0784_ _0782_ _0788_ VGND VGND VPWR VPWR _0859_ sky130_fd_sc_hd__a21bo_1
X_3153_ _1275_ VGND VGND VPWR VPWR _0184_ sky130_fd_sc_hd__clkbuf_1
X_3222_ _0287_ _0494_ VGND VGND VPWR VPWR _1314_ sky130_fd_sc_hd__or2_1
X_2104_ _0322_ VGND VGND VPWR VPWR _0323_ sky130_fd_sc_hd__buf_2
XTAP_146 VGND VPWR sky130_fd_sc_hd__tapvpwrvgnd_1
XTAP_135 VGND VPWR sky130_fd_sc_hd__tapvpwrvgnd_1
XTAP_124 VGND VPWR sky130_fd_sc_hd__tapvpwrvgnd_1
XTAP_157 VGND VPWR sky130_fd_sc_hd__tapvpwrvgnd_1
XTAP_168 VGND VPWR sky130_fd_sc_hd__tapvpwrvgnd_1
XTAP_179 VGND VPWR sky130_fd_sc_hd__tapvpwrvgnd_1
X_2035_ _1710_ VGND VGND VPWR VPWR _0066_ sky130_fd_sc_hd__clkbuf_1
X_3084_ _0974_ _1230_ VGND VGND VPWR VPWR _1231_ sky130_fd_sc_hd__nor2_1
X_2868_ RX.uart_cpb\[11\] _1031_ _1033_ RX.uart_cpb\[10\] _1034_ VGND VGND VPWR VPWR
+ _1045_ sky130_fd_sc_hd__o221a_1
X_2937_ _1103_ _1105_ _1110_ _1113_ VGND VGND VPWR VPWR _1114_ sky130_fd_sc_hd__or4_1
X_2799_ _0748_ RX.baud_cnt\[29\] RX.baud_cnt\[28\] _0749_ VGND VGND VPWR VPWR _0976_
+ sky130_fd_sc_hd__a22o_1
X_1819_ _1545_ _1536_ _1546_ _1547_ VGND VGND VPWR VPWR _1548_ sky130_fd_sc_hd__a211o_1
XFILLER_0_54_363 VGND VGND VPWR VPWR sky130_fd_sc_hd__fill_1
X_2722_ _0897_ _0347_ _0898_ VGND VGND VPWR VPWR _0899_ sky130_fd_sc_hd__a21o_1
Xclkbuf_leaf_1_S_AXI_ACLK clknet_1_0__leaf_S_AXI_ACLK VGND VGND VPWR VPWR clknet_leaf_1_S_AXI_ACLK
+ sky130_fd_sc_hd__clkbuf_16
X_2584_ _0704_ _0714_ VGND VGND VPWR VPWR _0773_ sky130_fd_sc_hd__xor2_2
X_2653_ TX.baud_counter\[12\] _0803_ _0840_ TX.baud_counter\[11\] VGND VGND VPWR VPWR
+ _0842_ sky130_fd_sc_hd__o22a_1
XFILLER_0_22_260 VGND VGND VPWR VPWR sky130_fd_sc_hd__fill_1
X_3136_ net234 VGND VGND VPWR VPWR _1267_ sky130_fd_sc_hd__clkbuf_1
X_3205_ _1304_ VGND VGND VPWR VPWR _1305_ sky130_fd_sc_hd__buf_2
X_3067_ _0895_ _1160_ VGND VGND VPWR VPWR _1219_ sky130_fd_sc_hd__nor2_1
X_2018_ _1677_ _1698_ VGND VGND VPWR VPWR _1699_ sky130_fd_sc_hd__and2_1
Xhold150 RX.uart_stp\[24\] VGND VGND VPWR VPWR net317 sky130_fd_sc_hd__dlygate4sd3_1
Xhold161 TX.data_latch_next\[7\] VGND VGND VPWR VPWR net328 sky130_fd_sc_hd__dlygate4sd3_1
XFILLER_0_24_85 VGND VGND VPWR VPWR sky130_fd_sc_hd__decap_4
XFILLER_0_24_41 VGND VGND VPWR VPWR sky130_fd_sc_hd__fill_1
X_2705_ net250 _0884_ VGND VGND VPWR VPWR _0888_ sky130_fd_sc_hd__or2_1
X_3685_ clknet_leaf_20_S_AXI_ACLK _0250_ net147 VGND VGND VPWR VPWR TX.baud_counter\[16\]
+ sky130_fd_sc_hd__dfrtp_4
X_2636_ _0612_ _0639_ VGND VGND VPWR VPWR _0825_ sky130_fd_sc_hd__or2b_1
X_2567_ _1639_ RX.uart_cpb\[28\] RX.uart_cpb\[29\] VGND VGND VPWR VPWR _0756_ sky130_fd_sc_hd__o21ai_1
X_2498_ _0577_ _0684_ _0685_ _0686_ VGND VGND VPWR VPWR _0687_ sky130_fd_sc_hd__a31o_1
X_3119_ _1243_ _1251_ VGND VGND VPWR VPWR _1256_ sky130_fd_sc_hd__or2_1
XFILLER_0_28_127 VGND VGND VPWR VPWR sky130_fd_sc_hd__fill_1
X_3470_ clknet_leaf_4_S_AXI_ACLK _0035_ VGND VGND VPWR VPWR net130 sky130_fd_sc_hd__dfxtp_1
X_2283_ _0295_ VGND VGND VPWR VPWR _0487_ sky130_fd_sc_hd__clkbuf_4
X_2352_ RX.uart_cpb\[13\] RX.uart_cpb\[12\] VGND VGND VPWR VPWR _0541_ sky130_fd_sc_hd__nand2_2
X_2421_ _0607_ _0525_ _0608_ _0589_ VGND VGND VPWR VPWR _0610_ sky130_fd_sc_hd__a31o_1
XFILLER_0_29_7 VGND VGND VPWR VPWR sky130_fd_sc_hd__fill_1
XFILLER_0_51_50 VGND VGND VPWR VPWR sky130_fd_sc_hd__fill_1
X_1998_ _1677_ _1684_ VGND VGND VPWR VPWR _1685_ sky130_fd_sc_hd__and2_1
X_3668_ clknet_leaf_11_S_AXI_ACLK _0233_ net160 VGND VGND VPWR VPWR RX.done_reg sky130_fd_sc_hd__dfrtp_4
X_3599_ clknet_leaf_11_S_AXI_ACLK _0164_ net160 VGND VGND VPWR VPWR RX.bit_idx\[0\]
+ sky130_fd_sc_hd__dfrtp_1
X_2619_ _0629_ _0635_ VGND VGND VPWR VPWR _0808_ sky130_fd_sc_hd__xor2_2
X_1852_ _1571_ net173 _1561_ _1574_ VGND VGND VPWR VPWR _0019_ sky130_fd_sc_hd__o211a_1
X_1921_ _1609_ net171 _1600_ _1628_ VGND VGND VPWR VPWR _0034_ sky130_fd_sc_hd__o211a_1
X_2970_ RX.state\[0\] _1057_ VGND VGND VPWR VPWR _1147_ sky130_fd_sc_hd__nand2_1
X_1783_ net26 _1510_ VGND VGND VPWR VPWR _1517_ sky130_fd_sc_hd__or2_1
X_3453_ clknet_leaf_11_S_AXI_ACLK _0018_ VGND VGND VPWR VPWR net112 sky130_fd_sc_hd__dfxtp_1
XFILLER_0_24_185 VGND VGND VPWR VPWR sky130_fd_sc_hd__fill_1
X_3522_ clknet_leaf_14_S_AXI_ACLK _0087_ VGND VGND VPWR VPWR RX.uart_stp\[7\] sky130_fd_sc_hd__dfxtp_1
XFILLER_0_21_64 VGND VGND VPWR VPWR sky130_fd_sc_hd__fill_2
X_2404_ _0540_ _0542_ VGND VGND VPWR VPWR _0593_ sky130_fd_sc_hd__nor2_1
X_2266_ net257 _0474_ _0475_ _0473_ VGND VGND VPWR VPWR _0097_ sky130_fd_sc_hd__o22a_1
X_3384_ _1381_ _1429_ VGND VGND VPWR VPWR _1430_ sky130_fd_sc_hd__nor2_1
X_2335_ RX.uart_cpb\[5\] RX.uart_cpb\[4\] VGND VGND VPWR VPWR _0524_ sky130_fd_sc_hd__xor2_1
X_2197_ RX.uart_cpb\[16\] VGND VGND VPWR VPWR _0408_ sky130_fd_sc_hd__inv_2
Xhold10 net120 VGND VGND VPWR VPWR net177 sky130_fd_sc_hd__dlygate4sd3_1
Xhold98 TX.uart_tdr\[10\] VGND VGND VPWR VPWR net265 sky130_fd_sc_hd__dlygate4sd3_1
Xhold65 TX.uart_tdr\[29\] VGND VGND VPWR VPWR net232 sky130_fd_sc_hd__dlygate4sd3_1
Xhold54 net130 VGND VGND VPWR VPWR net221 sky130_fd_sc_hd__dlygate4sd3_1
Xhold32 net142 VGND VGND VPWR VPWR net199 sky130_fd_sc_hd__dlygate4sd3_1
Xhold76 RX.uart_stp\[31\] VGND VGND VPWR VPWR net243 sky130_fd_sc_hd__dlygate4sd3_1
Xhold43 RX.uart_stp\[3\] VGND VGND VPWR VPWR net210 sky130_fd_sc_hd__dlygate4sd3_1
Xhold21 _0101_ VGND VGND VPWR VPWR net188 sky130_fd_sc_hd__dlygate4sd3_1
Xhold87 RX.uart_stp\[6\] VGND VGND VPWR VPWR net254 sky130_fd_sc_hd__dlygate4sd3_1
XFILLER_0_53_269 VGND VGND VPWR VPWR sky130_fd_sc_hd__fill_1
XANTENNA_7 net123 VGND VGND VPWR VPWR sky130_fd_sc_hd__diode_2
XTAP_339 VGND VPWR sky130_fd_sc_hd__tapvpwrvgnd_1
XTAP_328 VGND VPWR sky130_fd_sc_hd__tapvpwrvgnd_1
XTAP_317 VGND VPWR sky130_fd_sc_hd__tapvpwrvgnd_1
XTAP_306 VGND VPWR sky130_fd_sc_hd__tapvpwrvgnd_1
X_2120_ net328 _0324_ VGND VGND VPWR VPWR _0332_ sky130_fd_sc_hd__or2_1
X_2051_ net60 _1477_ VGND VGND VPWR VPWR _0286_ sky130_fd_sc_hd__or2_1
XFILLER_0_29_222 VGND VGND VPWR VPWR sky130_fd_sc_hd__fill_2
X_1904_ _1609_ net168 _1600_ _1615_ VGND VGND VPWR VPWR _0030_ sky130_fd_sc_hd__o211a_1
X_1835_ _1534_ net241 _1524_ _1560_ VGND VGND VPWR VPWR _0016_ sky130_fd_sc_hd__o211a_1
X_2953_ _0755_ _0769_ RX.baud_cnt\[29\] VGND VGND VPWR VPWR _1130_ sky130_fd_sc_hd__a21o_1
X_2884_ RX.baud_cnt\[0\] _0623_ _0813_ RX.baud_cnt\[1\] VGND VGND VPWR VPWR _1061_
+ sky130_fd_sc_hd__a22o_1
X_3505_ clknet_leaf_3_S_AXI_ACLK _0070_ VGND VGND VPWR VPWR uart_rdr\[30\] sky130_fd_sc_hd__dfxtp_1
X_3436_ clknet_leaf_4_S_AXI_ACLK _0001_ VGND VGND VPWR VPWR TX.uart_tdr\[25\] sky130_fd_sc_hd__dfxtp_1
X_1766_ net14 net13 net16 net15 VGND VGND VPWR VPWR _1500_ sky130_fd_sc_hd__or4_1
X_2318_ RX.uart_cpb\[23\] RX.uart_cpb\[22\] VGND VGND VPWR VPWR _0507_ sky130_fd_sc_hd__nand2_1
X_3298_ TX.baud_counter\[5\] TX.baud_counter\[4\] _1360_ VGND VGND VPWR VPWR _1366_
+ sky130_fd_sc_hd__and3_1
X_3367_ TX.baud_counter\[22\] TX.baud_counter\[21\] _1410_ TX.baud_counter\[23\] VGND
+ VGND VPWR VPWR _1417_ sky130_fd_sc_hd__a31o_1
X_2249_ TX.baud_counter\[31\] _0451_ VGND VGND VPWR VPWR _0460_ sky130_fd_sc_hd__or2_1
Xinput100 S_AXI_WDATA[8] VGND VGND VPWR VPWR net100 sky130_fd_sc_hd__buf_1
XFILLER_0_1_314 VPWR VGND VPWR VGND sky130_ef_sc_hd__decap_12
X_3152_ net228 VGND VGND VPWR VPWR _1275_ sky130_fd_sc_hd__clkbuf_1
X_3221_ net85 _1305_ _1313_ _1302_ VGND VGND VPWR VPWR _0214_ sky130_fd_sc_hd__o211a_1
X_2103_ _1479_ _0288_ VGND VGND VPWR VPWR _0322_ sky130_fd_sc_hd__or2_1
XTAP_147 VGND VPWR sky130_fd_sc_hd__tapvpwrvgnd_1
XTAP_136 VGND VPWR sky130_fd_sc_hd__tapvpwrvgnd_1
XTAP_125 VGND VPWR sky130_fd_sc_hd__tapvpwrvgnd_1
XTAP_158 VGND VPWR sky130_fd_sc_hd__tapvpwrvgnd_1
XTAP_169 VGND VPWR sky130_fd_sc_hd__tapvpwrvgnd_1
X_3083_ RX.baud_cnt\[28\] _0959_ _1226_ VGND VGND VPWR VPWR _1230_ sky130_fd_sc_hd__and3_1
X_2034_ _1700_ _1709_ VGND VGND VPWR VPWR _1710_ sky130_fd_sc_hd__and2_1
X_2798_ net107 _0974_ VGND VGND VPWR VPWR _0975_ sky130_fd_sc_hd__nand2_1
X_1818_ uart_rdr\[5\] _1538_ _1495_ VGND VGND VPWR VPWR _1547_ sky130_fd_sc_hd__a21bo_1
X_2867_ _1557_ _1026_ VGND VGND VPWR VPWR _1044_ sky130_fd_sc_hd__nor2_1
X_2936_ _1112_ _1100_ _1101_ VGND VGND VPWR VPWR _1113_ sky130_fd_sc_hd__o21a_1
X_1749_ net88 _1482_ _1488_ _1486_ VGND VGND VPWR VPWR _0002_ sky130_fd_sc_hd__o211a_1
X_3419_ net233 _1451_ VGND VGND VPWR VPWR _1452_ sky130_fd_sc_hd__or2_1
XFILLER_0_48_350 VGND VGND VPWR VPWR sky130_fd_sc_hd__fill_2
XFILLER_0_48_29 VGND VGND VPWR VPWR sky130_fd_sc_hd__fill_1
XFILLER_0_13_65 VGND VGND VPWR VPWR sky130_fd_sc_hd__fill_1
X_2652_ TX.baud_counter\[11\] _0840_ _0836_ TX.baud_counter\[10\] VGND VGND VPWR VPWR
+ _0841_ sky130_fd_sc_hd__a22o_1
X_2721_ RX.baud_cnt\[21\] _0351_ VGND VGND VPWR VPWR _0898_ sky130_fd_sc_hd__and2_1
X_3204_ _1303_ VGND VGND VPWR VPWR _1304_ sky130_fd_sc_hd__buf_2
XFILLER_0_22_283 VGND VGND VPWR VPWR sky130_fd_sc_hd__fill_1
X_2583_ TX.baud_counter\[28\] _0771_ _0770_ TX.baud_counter\[29\] VGND VGND VPWR VPWR
+ _0772_ sky130_fd_sc_hd__a22o_1
X_2017_ _1690_ RX.rx_shifter\[21\] _1695_ uart_rdr\[21\] VGND VGND VPWR VPWR _1698_
+ sky130_fd_sc_hd__a22o_1
XFILLER_0_54_72 VGND VGND VPWR VPWR sky130_fd_sc_hd__fill_2
X_3135_ _1266_ VGND VGND VPWR VPWR _0175_ sky130_fd_sc_hd__clkbuf_1
X_3066_ _0897_ _1216_ _1218_ VGND VGND VPWR VPWR _0154_ sky130_fd_sc_hd__o21a_1
X_2919_ _0904_ _0790_ VGND VGND VPWR VPWR _1096_ sky130_fd_sc_hd__and2_1
Xhold162 TX.data_latch_next\[0\] VGND VGND VPWR VPWR net329 sky130_fd_sc_hd__dlygate4sd3_1
Xhold140 TX.data_latch\[1\] VGND VGND VPWR VPWR net307 sky130_fd_sc_hd__dlygate4sd3_1
Xhold151 TX.data_latch_next\[2\] VGND VGND VPWR VPWR net318 sky130_fd_sc_hd__dlygate4sd3_1
XFILLER_0_55_106 VGND VGND VPWR VPWR sky130_fd_sc_hd__fill_1
XFILLER_0_51_334 VGND VGND VPWR VPWR sky130_fd_sc_hd__fill_2
X_2704_ net79 _0883_ _0887_ _0502_ VGND VGND VPWR VPWR _0123_ sky130_fd_sc_hd__o211a_1
X_2635_ TX.baud_counter\[4\] _0820_ _0823_ TX.baud_counter\[5\] VGND VGND VPWR VPWR
+ _0824_ sky130_fd_sc_hd__a22o_1
XFILLER_0_6_236 VGND VGND VPWR VPWR sky130_fd_sc_hd__decap_4
XFILLER_0_6_247 VGND VGND VPWR VPWR sky130_fd_sc_hd__decap_4
X_3684_ clknet_leaf_20_S_AXI_ACLK _0249_ net147 VGND VGND VPWR VPWR TX.baud_counter\[15\]
+ sky130_fd_sc_hd__dfrtp_4
X_2566_ _0738_ _0746_ _0754_ VGND VGND VPWR VPWR _0755_ sky130_fd_sc_hd__nand3_4
X_2497_ RX.uart_cpb\[16\] _1526_ _0582_ RX.uart_cpb\[17\] VGND VGND VPWR VPWR _0686_
+ sky130_fd_sc_hd__a22o_1
XFILLER_0_10_253 VGND VGND VPWR VPWR sky130_fd_sc_hd__decap_4
X_3118_ _1255_ VGND VGND VPWR VPWR _0169_ sky130_fd_sc_hd__clkbuf_1
X_3049_ _1153_ _1204_ VGND VGND VPWR VPWR _1206_ sky130_fd_sc_hd__nor2_1
XFILLER_0_33_334 VGND VGND VPWR VPWR sky130_fd_sc_hd__fill_2
XFILLER_0_18_331 VGND VGND VPWR VPWR sky130_fd_sc_hd__fill_1
XFILLER_0_51_164 VGND VGND VPWR VPWR sky130_fd_sc_hd__fill_1
X_2420_ _0607_ _0608_ _0525_ VGND VGND VPWR VPWR _0609_ sky130_fd_sc_hd__a21oi_1
X_2282_ net309 _0484_ VGND VGND VPWR VPWR _0486_ sky130_fd_sc_hd__or2_1
X_2351_ _0538_ _0539_ VGND VGND VPWR VPWR _0540_ sky130_fd_sc_hd__nand2_1
XFILLER_0_19_31 VGND VGND VPWR VPWR sky130_fd_sc_hd__decap_3
XFILLER_0_19_64 VGND VGND VPWR VPWR sky130_fd_sc_hd__decap_3
XFILLER_0_35_96 VGND VGND VPWR VPWR sky130_fd_sc_hd__fill_1
X_1997_ _1667_ RX.rx_shifter\[15\] _1672_ uart_rdr\[15\] VGND VGND VPWR VPWR _1684_
+ sky130_fd_sc_hd__a22o_1
XFILLER_0_42_131 VGND VGND VPWR VPWR sky130_fd_sc_hd__fill_1
X_2549_ _0722_ _0732_ _0737_ VGND VGND VPWR VPWR _0738_ sky130_fd_sc_hd__and3_2
X_3598_ clknet_leaf_5_S_AXI_ACLK net279 net156 VGND VGND VPWR VPWR RX.baud_cnt\[31\]
+ sky130_fd_sc_hd__dfrtp_2
XFILLER_0_2_250 VGND VGND VPWR VPWR sky130_fd_sc_hd__fill_2
XFILLER_0_15_356 VGND VGND VPWR VPWR sky130_fd_sc_hd__fill_1
X_2618_ _0606_ _0806_ VGND VGND VPWR VPWR _0807_ sky130_fd_sc_hd__xnor2_2
X_3667_ clknet_leaf_12_S_AXI_ACLK _0232_ net157 VGND VGND VPWR VPWR TX.state\[1\]
+ sky130_fd_sc_hd__dfrtp_4
XFILLER_0_33_153 VPWR VGND VPWR VGND sky130_ef_sc_hd__decap_12
XFILLER_0_56_18 VGND VGND VPWR VPWR sky130_fd_sc_hd__fill_1
X_1920_ _1625_ _1521_ _1626_ _1627_ VGND VGND VPWR VPWR _1628_ sky130_fd_sc_hd__a211o_1
X_1851_ RX.uart_cpb\[11\] _1536_ _1572_ _1573_ VGND VGND VPWR VPWR _1574_ sky130_fd_sc_hd__a211o_1
X_1782_ net28 net30 net29 net27 VGND VGND VPWR VPWR _1516_ sky130_fd_sc_hd__or4b_1
X_3452_ clknet_leaf_11_S_AXI_ACLK _0017_ VGND VGND VPWR VPWR net142 sky130_fd_sc_hd__dfxtp_1
X_2403_ _0587_ _0590_ _0591_ VGND VGND VPWR VPWR _0592_ sky130_fd_sc_hd__o21ba_1
XFILLER_0_24_197 VGND VGND VPWR VPWR sky130_fd_sc_hd__fill_2
X_3521_ clknet_leaf_14_S_AXI_ACLK _0086_ VGND VGND VPWR VPWR RX.uart_stp\[6\] sky130_fd_sc_hd__dfxtp_1
X_3383_ TX.baud_counter\[27\] _1426_ VGND VGND VPWR VPWR _1429_ sky130_fd_sc_hd__and2_1
XFILLER_0_21_87 VGND VGND VPWR VPWR sky130_fd_sc_hd__fill_2
X_2334_ _0519_ _0520_ _0521_ _0522_ VGND VGND VPWR VPWR _0523_ sky130_fd_sc_hd__o31ai_4
X_2265_ _1463_ _0470_ VGND VGND VPWR VPWR _0475_ sky130_fd_sc_hd__nor2_1
X_2196_ TX.baud_counter\[14\] _0400_ _0406_ TX.baud_counter\[15\] VGND VGND VPWR VPWR
+ _0407_ sky130_fd_sc_hd__a22o_1
XFILLER_0_30_112 VGND VGND VPWR VPWR sky130_fd_sc_hd__fill_1
Xhold22 net114 VGND VGND VPWR VPWR net189 sky130_fd_sc_hd__dlygate4sd3_1
Xhold11 net134 VGND VGND VPWR VPWR net178 sky130_fd_sc_hd__dlygate4sd3_1
Xhold88 RX.uart_stp\[17\] VGND VGND VPWR VPWR net255 sky130_fd_sc_hd__dlygate4sd3_1
Xhold99 TX.uart_tdr\[12\] VGND VGND VPWR VPWR net266 sky130_fd_sc_hd__dlygate4sd3_1
Xhold66 RX.uart_stp\[8\] VGND VGND VPWR VPWR net233 sky130_fd_sc_hd__dlygate4sd3_1
Xhold33 TX.uart_tdr\[31\] VGND VGND VPWR VPWR net200 sky130_fd_sc_hd__dlygate4sd3_1
Xhold55 TX.uart_tdr\[27\] VGND VGND VPWR VPWR net222 sky130_fd_sc_hd__dlygate4sd3_1
Xhold44 RX.uart_stp\[9\] VGND VGND VPWR VPWR net211 sky130_fd_sc_hd__dlygate4sd3_1
Xhold77 TX.baud_counter\[3\] VGND VGND VPWR VPWR net244 sky130_fd_sc_hd__dlygate4sd3_1
XFILLER_0_38_201 VGND VGND VPWR VPWR sky130_fd_sc_hd__fill_2
XANTENNA_8 net126 VGND VGND VPWR VPWR sky130_fd_sc_hd__diode_2
X_2050_ _0285_ VGND VGND VPWR VPWR _0071_ sky130_fd_sc_hd__clkbuf_1
XTAP_329 VGND VPWR sky130_fd_sc_hd__tapvpwrvgnd_1
XTAP_318 VGND VPWR sky130_fd_sc_hd__tapvpwrvgnd_1
XTAP_307 VGND VPWR sky130_fd_sc_hd__tapvpwrvgnd_1
X_2952_ RX.baud_cnt\[30\] _0767_ _1128_ VGND VGND VPWR VPWR _1129_ sky130_fd_sc_hd__a21o_1
X_1903_ RX.uart_cpb\[22\] _1578_ _1613_ _1614_ VGND VGND VPWR VPWR _1615_ sky130_fd_sc_hd__a211o_1
X_1834_ _1557_ _1536_ _1558_ _1559_ VGND VGND VPWR VPWR _1560_ sky130_fd_sc_hd__a211o_1
XFILLER_0_44_226 VGND VGND VPWR VPWR sky130_fd_sc_hd__decap_3
X_1765_ net18 net17 net20 net19 VGND VGND VPWR VPWR _1499_ sky130_fd_sc_hd__or4_1
XFILLER_0_29_256 VGND VGND VPWR VPWR sky130_fd_sc_hd__fill_1
X_2883_ RX.baud_cnt\[1\] _0813_ VGND VGND VPWR VPWR _1060_ sky130_fd_sc_hd__or2_1
X_3504_ clknet_leaf_3_S_AXI_ACLK _0069_ VGND VGND VPWR VPWR uart_rdr\[29\] sky130_fd_sc_hd__dfxtp_1
X_3435_ clknet_leaf_3_S_AXI_ACLK _0000_ VGND VGND VPWR VPWR TX.uart_tdr\[24\] sky130_fd_sc_hd__dfxtp_1
X_3366_ TX.baud_counter\[22\] _1355_ _1350_ _1416_ VGND VGND VPWR VPWR _0256_ sky130_fd_sc_hd__a22o_1
XFILLER_0_12_156 VGND VGND VPWR VPWR sky130_fd_sc_hd__fill_2
X_2317_ net76 _0496_ _0506_ _0502_ VGND VGND VPWR VPWR _0117_ sky130_fd_sc_hd__o211a_1
XFILLER_0_32_3 VGND VGND VPWR VPWR sky130_fd_sc_hd__fill_1
X_2179_ RX.uart_cpb\[11\] _0389_ _0338_ VGND VGND VPWR VPWR _0390_ sky130_fd_sc_hd__a21boi_2
X_2248_ TX.baud_counter\[28\] _0456_ _0458_ TX.baud_counter\[29\] VGND VGND VPWR VPWR
+ _0459_ sky130_fd_sc_hd__a22o_1
X_3297_ TX.baud_counter\[4\] _1360_ TX.baud_counter\[5\] VGND VGND VPWR VPWR _1365_
+ sky130_fd_sc_hd__a21oi_1
Xinput101 S_AXI_WDATA[9] VGND VGND VPWR VPWR net101 sky130_fd_sc_hd__clkbuf_2
X_3220_ _0348_ _1304_ VGND VGND VPWR VPWR _1313_ sky130_fd_sc_hd__nand2_1
XTAP_148 VGND VPWR sky130_fd_sc_hd__tapvpwrvgnd_1
XTAP_137 VGND VPWR sky130_fd_sc_hd__tapvpwrvgnd_1
XFILLER_0_1_337 VGND VGND VPWR VPWR sky130_fd_sc_hd__decap_8
XFILLER_0_1_326 VGND VGND VPWR VPWR sky130_fd_sc_hd__decap_8
XTAP_126 VGND VPWR sky130_fd_sc_hd__tapvpwrvgnd_1
X_3151_ _1274_ VGND VGND VPWR VPWR _0183_ sky130_fd_sc_hd__clkbuf_1
X_2033_ _1690_ RX.rx_shifter\[26\] _1695_ uart_rdr\[26\] VGND VGND VPWR VPWR _1709_
+ sky130_fd_sc_hd__a22o_1
XTAP_159 VGND VPWR sky130_fd_sc_hd__tapvpwrvgnd_1
X_3082_ _0959_ _1226_ RX.baud_cnt\[28\] VGND VGND VPWR VPWR _1229_ sky130_fd_sc_hd__a21o_1
X_2102_ net99 _0309_ _0320_ _0321_ VGND VGND VPWR VPWR _0087_ sky130_fd_sc_hd__o211a_1
X_2935_ _0902_ _0798_ _1097_ VGND VGND VPWR VPWR _1112_ sky130_fd_sc_hd__o21a_1
X_1748_ net260 _1483_ VGND VGND VPWR VPWR _1488_ sky130_fd_sc_hd__or2_1
X_2797_ RX.state\[0\] RX.state\[1\] VGND VGND VPWR VPWR _0974_ sky130_fd_sc_hd__nor2_4
XFILLER_0_25_281 VGND VGND VPWR VPWR sky130_fd_sc_hd__fill_1
X_2866_ _1029_ _1032_ _1035_ _1042_ VGND VGND VPWR VPWR _1043_ sky130_fd_sc_hd__or4_1
X_1817_ TX.data_latch_next\[5\] _1507_ _1509_ RX.uart_stp\[5\] VGND VGND VPWR VPWR
+ _1546_ sky130_fd_sc_hd__a22o_1
XFILLER_0_40_284 VGND VGND VPWR VPWR sky130_fd_sc_hd__fill_1
X_3418_ _0307_ _0494_ VGND VGND VPWR VPWR _1451_ sky130_fd_sc_hd__nor2_2
X_3349_ TX.baud_counter\[18\] _1401_ VGND VGND VPWR VPWR _1404_ sky130_fd_sc_hd__or2_1
XFILLER_0_31_273 VGND VGND VPWR VPWR sky130_fd_sc_hd__fill_2
XFILLER_0_31_240 VGND VGND VPWR VPWR sky130_fd_sc_hd__fill_2
XFILLER_0_54_321 VPWR VGND VPWR VGND sky130_ef_sc_hd__decap_12
X_2582_ _0738_ _0746_ VGND VGND VPWR VPWR _0771_ sky130_fd_sc_hd__xor2_2
X_2720_ RX.baud_cnt\[22\] VGND VGND VPWR VPWR _0897_ sky130_fd_sc_hd__clkbuf_4
X_2651_ _0660_ _0839_ VGND VGND VPWR VPWR _0840_ sky130_fd_sc_hd__nor2_2
XFILLER_0_22_240 VGND VGND VPWR VPWR sky130_fd_sc_hd__fill_2
XFILLER_0_22_251 VGND VGND VPWR VPWR sky130_fd_sc_hd__fill_1
X_3203_ _0287_ _0481_ VGND VGND VPWR VPWR _1303_ sky130_fd_sc_hd__or2_1
XFILLER_0_1_167 VGND VGND VPWR VPWR sky130_fd_sc_hd__fill_1
X_2016_ _1697_ VGND VGND VPWR VPWR _0060_ sky130_fd_sc_hd__clkbuf_1
X_3134_ net253 VGND VGND VPWR VPWR _1266_ sky130_fd_sc_hd__clkbuf_1
X_3065_ _1176_ _1217_ _1152_ VGND VGND VPWR VPWR _1218_ sky130_fd_sc_hd__o21bai_1
X_2918_ _0936_ _0850_ _1075_ _1090_ _1094_ VGND VGND VPWR VPWR _1095_ sky130_fd_sc_hd__o221a_1
Xhold130 TX.uart_tdr\[23\] VGND VGND VPWR VPWR net297 sky130_fd_sc_hd__dlygate4sd3_1
Xhold163 RX.rx_shifter\[4\] VGND VGND VPWR VPWR net330 sky130_fd_sc_hd__dlygate4sd3_1
X_2849_ RX.baud_cnt\[7\] VGND VGND VPWR VPWR _1026_ sky130_fd_sc_hd__inv_2
Xhold152 TX.data_latch\[5\] VGND VGND VPWR VPWR net319 sky130_fd_sc_hd__dlygate4sd3_1
XFILLER_0_13_251 VGND VGND VPWR VPWR sky130_fd_sc_hd__fill_1
Xhold141 _1442_ VGND VGND VPWR VPWR net308 sky130_fd_sc_hd__dlygate4sd3_1
Xclkbuf_leaf_20_S_AXI_ACLK clknet_1_0__leaf_S_AXI_ACLK VGND VGND VPWR VPWR clknet_leaf_20_S_AXI_ACLK
+ sky130_fd_sc_hd__clkbuf_16
XFILLER_0_42_324 VGND VGND VPWR VPWR sky130_fd_sc_hd__fill_1
X_2703_ net294 _0884_ VGND VGND VPWR VPWR _0887_ sky130_fd_sc_hd__or2_1
X_2565_ _0589_ _0751_ _0752_ _0753_ VGND VGND VPWR VPWR _0754_ sky130_fd_sc_hd__o31a_1
X_3683_ clknet_leaf_20_S_AXI_ACLK _0248_ net153 VGND VGND VPWR VPWR TX.baud_counter\[14\]
+ sky130_fd_sc_hd__dfrtp_4
X_2634_ _0639_ _0612_ VGND VGND VPWR VPWR _0823_ sky130_fd_sc_hd__xnor2_2
X_3117_ net107 net315 _1254_ VGND VGND VPWR VPWR _1255_ sky130_fd_sc_hd__mux2_1
X_2496_ _0551_ _0553_ _0677_ VGND VGND VPWR VPWR _0685_ sky130_fd_sc_hd__nand3_1
XFILLER_0_10_265 VGND VGND VPWR VPWR sky130_fd_sc_hd__decap_4
X_3048_ _1194_ _1204_ _1205_ _1186_ _0902_ VGND VGND VPWR VPWR _0149_ sky130_fd_sc_hd__a32o_1
X_2281_ net77 _0483_ _0485_ _0321_ VGND VGND VPWR VPWR _0102_ sky130_fd_sc_hd__o211a_1
X_2350_ RX.uart_cpb\[14\] RX.uart_cpb\[13\] VGND VGND VPWR VPWR _0539_ sky130_fd_sc_hd__or2_1
XFILLER_0_19_10 VGND VGND VPWR VPWR sky130_fd_sc_hd__fill_1
XFILLER_0_19_98 VGND VGND VPWR VPWR sky130_fd_sc_hd__decap_6
X_1996_ _1683_ VGND VGND VPWR VPWR _0054_ sky130_fd_sc_hd__clkbuf_1
X_2548_ _0724_ _0313_ _0604_ _0441_ _0736_ VGND VGND VPWR VPWR _0737_ sky130_fd_sc_hd__o221a_1
X_3597_ clknet_1_0__leaf_S_AXI_ACLK _0162_ net156 VGND VGND VPWR VPWR RX.baud_cnt\[30\]
+ sky130_fd_sc_hd__dfrtp_4
X_3666_ clknet_leaf_12_S_AXI_ACLK _0231_ net158 VGND VGND VPWR VPWR TX.state\[0\]
+ sky130_fd_sc_hd__dfrtp_4
XFILLER_0_2_273 VGND VGND VPWR VPWR sky130_fd_sc_hd__fill_2
X_2617_ _0640_ _0644_ _0647_ VGND VGND VPWR VPWR _0806_ sky130_fd_sc_hd__and3_1
X_2479_ _0576_ _0661_ _0666_ _0667_ VGND VGND VPWR VPWR _0668_ sky130_fd_sc_hd__a31o_2
XFILLER_0_33_165 VGND VGND VPWR VPWR sky130_fd_sc_hd__decap_3
X_1850_ uart_rdr\[11\] _1538_ _1550_ VGND VGND VPWR VPWR _1573_ sky130_fd_sc_hd__a21bo_1
X_1781_ TX.data_latch_next\[0\] _1507_ _1509_ RX.uart_stp\[0\] _1514_ VGND VGND VPWR
+ VPWR _1515_ sky130_fd_sc_hd__a221o_1
X_3520_ clknet_leaf_14_S_AXI_ACLK _0085_ VGND VGND VPWR VPWR RX.uart_stp\[5\] sky130_fd_sc_hd__dfxtp_1
XFILLER_0_21_33 VGND VGND VPWR VPWR sky130_fd_sc_hd__fill_2
XFILLER_0_21_77 VGND VGND VPWR VPWR sky130_fd_sc_hd__decap_3
X_3451_ clknet_leaf_9_S_AXI_ACLK _0016_ VGND VGND VPWR VPWR net141 sky130_fd_sc_hd__dfxtp_1
X_2402_ _1596_ _1526_ _0582_ RX.uart_cpb\[19\] VGND VGND VPWR VPWR _0591_ sky130_fd_sc_hd__a22o_1
X_2333_ _1541_ _1532_ _1535_ VGND VGND VPWR VPWR _0522_ sky130_fd_sc_hd__o21ai_1
X_3382_ TX.baud_counter\[27\] _1426_ VGND VGND VPWR VPWR _1428_ sky130_fd_sc_hd__or2_1
X_2195_ _0341_ _0405_ VGND VGND VPWR VPWR _0406_ sky130_fd_sc_hd__and2_1
X_2264_ _0333_ _0469_ _0474_ VGND VGND VPWR VPWR _0096_ sky130_fd_sc_hd__a21oi_1
XFILLER_0_47_279 VGND VGND VPWR VPWR sky130_fd_sc_hd__fill_1
X_1979_ _1671_ VGND VGND VPWR VPWR _0049_ sky130_fd_sc_hd__clkbuf_1
X_3649_ clknet_leaf_0_S_AXI_ACLK _0214_ VGND VGND VPWR VPWR RX.uart_cpb\[23\] sky130_fd_sc_hd__dfxtp_2
XFILLER_0_15_187 VGND VGND VPWR VPWR sky130_fd_sc_hd__decap_6
Xhold23 net115 VGND VGND VPWR VPWR net190 sky130_fd_sc_hd__dlygate4sd3_1
Xhold34 RX.rx_shifter\[20\] VGND VGND VPWR VPWR net201 sky130_fd_sc_hd__dlygate4sd3_1
Xhold12 net118 VGND VGND VPWR VPWR net179 sky130_fd_sc_hd__dlygate4sd3_1
Xhold45 RX.rx_shifter\[31\] VGND VGND VPWR VPWR net212 sky130_fd_sc_hd__dlygate4sd3_1
Xhold56 TX.uart_tdr\[28\] VGND VGND VPWR VPWR net223 sky130_fd_sc_hd__dlygate4sd3_1
Xhold67 RX.rx_shifter\[9\] VGND VGND VPWR VPWR net234 sky130_fd_sc_hd__dlygate4sd3_1
Xhold78 TX.uart_tdr\[9\] VGND VGND VPWR VPWR net245 sky130_fd_sc_hd__dlygate4sd3_1
Xhold89 TX.baud_counter\[30\] VGND VGND VPWR VPWR net256 sky130_fd_sc_hd__dlygate4sd3_1
XTAP_319 VGND VPWR sky130_fd_sc_hd__tapvpwrvgnd_1
XTAP_308 VGND VPWR sky130_fd_sc_hd__tapvpwrvgnd_1
XANTENNA_9 net142 VGND VGND VPWR VPWR sky130_fd_sc_hd__diode_2
X_1902_ uart_rdr\[22\] _1580_ _1590_ VGND VGND VPWR VPWR _1614_ sky130_fd_sc_hd__a21bo_1
X_2951_ RX.baud_cnt\[29\] _0755_ _0769_ VGND VGND VPWR VPWR _1128_ sky130_fd_sc_hd__and3_1
XFILLER_0_16_66 VGND VGND VPWR VPWR sky130_fd_sc_hd__decap_3
X_3503_ clknet_leaf_2_S_AXI_ACLK _0068_ VGND VGND VPWR VPWR uart_rdr\[28\] sky130_fd_sc_hd__dfxtp_1
X_1833_ uart_rdr\[8\] _1538_ _1550_ VGND VGND VPWR VPWR _1559_ sky130_fd_sc_hd__a21bo_1
X_2882_ RX.baud_cnt\[5\] _0823_ VGND VGND VPWR VPWR _1059_ sky130_fd_sc_hd__nand2_1
X_1764_ net22 net21 net25 net24 VGND VGND VPWR VPWR _1498_ sky130_fd_sc_hd__or4_1
XFILLER_0_57_51 VGND VGND VPWR VPWR sky130_fd_sc_hd__fill_2
X_2316_ net194 _0497_ VGND VGND VPWR VPWR _0506_ sky130_fd_sc_hd__or2_1
X_3434_ net76 _1450_ _1459_ _1524_ VGND VGND VPWR VPWR _0281_ sky130_fd_sc_hd__o211a_1
X_3365_ TX.baud_counter\[22\] _1413_ _1415_ VGND VGND VPWR VPWR _1416_ sky130_fd_sc_hd__o21a_1
X_3296_ _1348_ VGND VGND VPWR VPWR _1364_ sky130_fd_sc_hd__clkbuf_4
X_2247_ _0447_ _0457_ VGND VGND VPWR VPWR _0458_ sky130_fd_sc_hd__and2_1
X_2178_ RX.uart_cpb\[10\] _1562_ _1557_ _0336_ VGND VGND VPWR VPWR _0389_ sky130_fd_sc_hd__or4_1
Xinput102 S_AXI_WSTRB[0] VGND VGND VPWR VPWR net102 sky130_fd_sc_hd__buf_1
X_3150_ net301 VGND VGND VPWR VPWR _1274_ sky130_fd_sc_hd__clkbuf_1
XTAP_149 VGND VPWR sky130_fd_sc_hd__tapvpwrvgnd_1
XTAP_138 VGND VPWR sky130_fd_sc_hd__tapvpwrvgnd_1
XTAP_127 VGND VPWR sky130_fd_sc_hd__tapvpwrvgnd_1
XTAP_116 VGND VPWR sky130_fd_sc_hd__tapvpwrvgnd_1
X_2032_ _1708_ VGND VGND VPWR VPWR _0065_ sky130_fd_sc_hd__clkbuf_1
X_2101_ _0295_ VGND VGND VPWR VPWR _0321_ sky130_fd_sc_hd__clkbuf_4
XFILLER_0_27_65 VGND VGND VPWR VPWR sky130_fd_sc_hd__decap_4
X_3081_ _1158_ _1226_ _1228_ _1227_ _0959_ VGND VGND VPWR VPWR _0159_ sky130_fd_sc_hd__a32o_1
XFILLER_0_57_352 VGND VGND VPWR VPWR sky130_fd_sc_hd__fill_2
X_2865_ _0649_ RX.baud_cnt\[8\] _1036_ _1038_ _1041_ VGND VGND VPWR VPWR _1042_ sky130_fd_sc_hd__a2111o_1
X_2934_ _1102_ _1103_ _1105_ _1110_ VGND VGND VPWR VPWR _1111_ sky130_fd_sc_hd__or4_2
X_1747_ net87 _1482_ _1487_ _1486_ VGND VGND VPWR VPWR _0001_ sky130_fd_sc_hd__o211a_1
X_2796_ RX.state\[1\] _0972_ VGND VGND VPWR VPWR _0973_ sky130_fd_sc_hd__nand2_1
X_1816_ RX.uart_cpb\[5\] VGND VGND VPWR VPWR _1545_ sky130_fd_sc_hd__buf_2
X_3417_ _1449_ VGND VGND VPWR VPWR _1450_ sky130_fd_sc_hd__buf_2
X_3279_ TX.baud_counter\[0\] TX.baud_counter\[1\] VGND VGND VPWR VPWR _1351_ sky130_fd_sc_hd__or2_1
X_3348_ _1342_ _1364_ _1402_ _1403_ net275 VGND VGND VPWR VPWR _0251_ sky130_fd_sc_hd__a32o_1
Xclkbuf_leaf_10_S_AXI_ACLK clknet_1_1__leaf_S_AXI_ACLK VGND VGND VPWR VPWR clknet_leaf_10_S_AXI_ACLK
+ sky130_fd_sc_hd__clkbuf_16
XFILLER_0_54_333 VPWR VGND VPWR VGND sky130_ef_sc_hd__decap_12
X_2581_ _0755_ _0769_ VGND VGND VPWR VPWR _0770_ sky130_fd_sc_hd__and2_1
XFILLER_0_14_208 VGND VGND VPWR VPWR sky130_fd_sc_hd__fill_1
X_2650_ _0648_ _0654_ _0659_ VGND VGND VPWR VPWR _0839_ sky130_fd_sc_hd__a21oi_1
X_3133_ _1265_ VGND VGND VPWR VPWR _0174_ sky130_fd_sc_hd__clkbuf_1
X_3202_ net94 _1292_ _1301_ _1302_ VGND VGND VPWR VPWR _0206_ sky130_fd_sc_hd__o211a_1
X_2015_ _1677_ _1696_ VGND VGND VPWR VPWR _1697_ sky130_fd_sc_hd__and2_1
XFILLER_0_54_85 VGND VGND VPWR VPWR sky130_fd_sc_hd__fill_1
XFILLER_0_54_41 VGND VGND VPWR VPWR sky130_fd_sc_hd__decap_4
X_3064_ _0897_ RX.baud_cnt\[21\] _1211_ VGND VGND VPWR VPWR _1217_ sky130_fd_sc_hd__and3_1
X_2848_ _1017_ _1023_ _1024_ VGND VGND VPWR VPWR _1025_ sky130_fd_sc_hd__o21ba_1
X_2917_ _1088_ _1093_ VGND VGND VPWR VPWR _1094_ sky130_fd_sc_hd__or2_1
Xhold142 TX.uart_tdr\[17\] VGND VGND VPWR VPWR net309 sky130_fd_sc_hd__dlygate4sd3_1
Xhold153 RX.uart_stp\[26\] VGND VGND VPWR VPWR net320 sky130_fd_sc_hd__dlygate4sd3_1
Xhold120 TX.baud_counter\[8\] VGND VGND VPWR VPWR net287 sky130_fd_sc_hd__dlygate4sd3_1
Xhold131 TX.data_latch\[0\] VGND VGND VPWR VPWR net298 sky130_fd_sc_hd__dlygate4sd3_1
X_2779_ RX.baud_cnt\[25\] _0434_ VGND VGND VPWR VPWR _0956_ sky130_fd_sc_hd__or2_1
XFILLER_0_24_33 VGND VGND VPWR VPWR sky130_fd_sc_hd__fill_1
XFILLER_0_54_141 VGND VGND VPWR VPWR sky130_fd_sc_hd__fill_1
X_2702_ net78 _0883_ _0886_ _0502_ VGND VGND VPWR VPWR _0122_ sky130_fd_sc_hd__o211a_1
X_3682_ clknet_leaf_19_S_AXI_ACLK _0247_ net150 VGND VGND VPWR VPWR TX.baud_counter\[13\]
+ sky130_fd_sc_hd__dfrtp_4
X_2564_ _0455_ _0313_ _0604_ _0749_ VGND VGND VPWR VPWR _0753_ sky130_fd_sc_hd__o22a_1
X_2495_ _0551_ _0677_ _0553_ VGND VGND VPWR VPWR _0684_ sky130_fd_sc_hd__a21o_1
X_2633_ _0809_ _0818_ _0820_ TX.baud_counter\[4\] _0821_ VGND VGND VPWR VPWR _0822_
+ sky130_fd_sc_hd__o221a_1
X_3116_ _0970_ _1251_ RX.bit_idx\[1\] VGND VGND VPWR VPWR _1254_ sky130_fd_sc_hd__or3b_1
X_3047_ _0902_ _1202_ _1163_ VGND VGND VPWR VPWR _1205_ sky130_fd_sc_hd__o21a_1
Xclkbuf_leaf_0_S_AXI_ACLK clknet_1_0__leaf_S_AXI_ACLK VGND VGND VPWR VPWR clknet_leaf_0_S_AXI_ACLK
+ sky130_fd_sc_hd__clkbuf_16
X_2280_ net258 _0484_ VGND VGND VPWR VPWR _0485_ sky130_fd_sc_hd__or2_1
XFILLER_0_35_43 VGND VGND VPWR VPWR sky130_fd_sc_hd__fill_2
X_1995_ _1677_ _1682_ VGND VGND VPWR VPWR _1683_ sky130_fd_sc_hd__and2_1
X_3665_ clknet_leaf_4_S_AXI_ACLK _0230_ VGND VGND VPWR VPWR RX.uart_stp\[31\] sky130_fd_sc_hd__dfxtp_1
X_2616_ _0800_ _0802_ VGND VGND VPWR VPWR _0805_ sky130_fd_sc_hd__and2_1
X_2547_ _0734_ _0735_ VGND VGND VPWR VPWR _0736_ sky130_fd_sc_hd__or2_1
X_2478_ RX.uart_cpb\[11\] _1525_ _0581_ RX.uart_cpb\[12\] VGND VGND VPWR VPWR _0667_
+ sky130_fd_sc_hd__a22o_1
X_3596_ clknet_leaf_17_S_AXI_ACLK _0161_ net154 VGND VGND VPWR VPWR RX.baud_cnt\[29\]
+ sky130_fd_sc_hd__dfrtp_4
XFILLER_0_33_111 VGND VGND VPWR VPWR sky130_fd_sc_hd__fill_1
X_1780_ uart_rdr\[0\] _1513_ _1494_ VGND VGND VPWR VPWR _1514_ sky130_fd_sc_hd__a21bo_1
XFILLER_0_24_100 VGND VGND VPWR VPWR sky130_fd_sc_hd__fill_1
X_2401_ _0555_ _0557_ _0586_ _0589_ VGND VGND VPWR VPWR _0590_ sky130_fd_sc_hd__a31o_1
X_2332_ RX.uart_cpb\[2\] RX.uart_cpb\[0\] RX.uart_cpb\[1\] VGND VGND VPWR VPWR _0521_
+ sky130_fd_sc_hd__o21ai_2
X_3450_ clknet_leaf_14_S_AXI_ACLK _0015_ VGND VGND VPWR VPWR net140 sky130_fd_sc_hd__dfxtp_1
X_3381_ _1342_ _1364_ _1427_ _1403_ net283 VGND VGND VPWR VPWR _0260_ sky130_fd_sc_hd__a32o_1
XFILLER_0_46_75 VGND VGND VPWR VPWR sky130_fd_sc_hd__fill_1
X_2194_ _0403_ _0396_ _0404_ VGND VGND VPWR VPWR _0405_ sky130_fd_sc_hd__a21o_1
X_2263_ _0333_ _0473_ VGND VGND VPWR VPWR _0474_ sky130_fd_sc_hd__nor2_1
XFILLER_0_1_55 VGND VGND VPWR VPWR sky130_fd_sc_hd__fill_1
XFILLER_0_1_77 VGND VGND VPWR VPWR sky130_fd_sc_hd__fill_1
X_1978_ _1654_ _1670_ VGND VGND VPWR VPWR _1671_ sky130_fd_sc_hd__and2_1
X_3648_ clknet_leaf_0_S_AXI_ACLK _0213_ VGND VGND VPWR VPWR RX.uart_cpb\[22\] sky130_fd_sc_hd__dfxtp_2
X_3579_ clknet_leaf_18_S_AXI_ACLK _0144_ net152 VGND VGND VPWR VPWR RX.baud_cnt\[12\]
+ sky130_fd_sc_hd__dfrtp_4
XFILLER_0_15_122 VGND VGND VPWR VPWR sky130_fd_sc_hd__fill_1
XFILLER_0_15_166 VGND VGND VPWR VPWR sky130_fd_sc_hd__fill_2
XFILLER_0_15_177 VGND VGND VPWR VPWR sky130_fd_sc_hd__fill_2
Xhold68 RX.rx_shifter\[25\] VGND VGND VPWR VPWR net235 sky130_fd_sc_hd__dlygate4sd3_1
Xhold35 RX.rx_shifter\[12\] VGND VGND VPWR VPWR net202 sky130_fd_sc_hd__dlygate4sd3_1
Xhold57 TX.uart_tdr\[18\] VGND VGND VPWR VPWR net224 sky130_fd_sc_hd__dlygate4sd3_1
Xhold24 TX.uart_tdr\[20\] VGND VGND VPWR VPWR net191 sky130_fd_sc_hd__dlygate4sd3_1
Xhold46 RX.uart_stp\[12\] VGND VGND VPWR VPWR net213 sky130_fd_sc_hd__dlygate4sd3_1
Xhold79 TX.baud_counter\[6\] VGND VGND VPWR VPWR net246 sky130_fd_sc_hd__dlygate4sd3_1
Xhold13 net140 VGND VGND VPWR VPWR net180 sky130_fd_sc_hd__dlygate4sd3_1
XFILLER_0_38_269 VGND VGND VPWR VPWR sky130_fd_sc_hd__fill_1
XTAP_309 VGND VPWR sky130_fd_sc_hd__tapvpwrvgnd_1
X_1901_ TX.uart_tdr\[22\] _1604_ _1605_ RX.uart_stp\[22\] VGND VGND VPWR VPWR _1613_
+ sky130_fd_sc_hd__a22o_1
X_1832_ TX.uart_tdr\[8\] _1507_ _1509_ net233 VGND VGND VPWR VPWR _1558_ sky130_fd_sc_hd__a22o_1
X_2881_ _0973_ _0975_ _1057_ RX.state\[0\] VGND VGND VPWR VPWR _1058_ sky130_fd_sc_hd__a31o_1
X_2950_ _1117_ _1119_ _1123_ _1125_ _1126_ VGND VGND VPWR VPWR _1127_ sky130_fd_sc_hd__o32a_1
X_3502_ clknet_leaf_2_S_AXI_ACLK _0067_ VGND VGND VPWR VPWR uart_rdr\[27\] sky130_fd_sc_hd__dfxtp_1
X_3433_ net249 _1451_ VGND VGND VPWR VPWR _1459_ sky130_fd_sc_hd__or2_1
X_1763_ net5 net7 net6 net4 VGND VGND VPWR VPWR _1497_ sky130_fd_sc_hd__or4bb_1
XFILLER_0_57_85 VGND VGND VPWR VPWR sky130_fd_sc_hd__fill_2
X_2315_ net75 _0496_ _0505_ _0502_ VGND VGND VPWR VPWR _0116_ sky130_fd_sc_hd__o211a_1
X_2246_ RX.uart_cpb\[28\] _0443_ RX.uart_cpb\[29\] VGND VGND VPWR VPWR _0457_ sky130_fd_sc_hd__o21ai_1
X_3364_ TX.baud_counter\[22\] _1413_ _1352_ VGND VGND VPWR VPWR _1415_ sky130_fd_sc_hd__a21oi_1
X_3295_ _1350_ _1362_ _1363_ _1355_ TX.baud_counter\[4\] VGND VGND VPWR VPWR _0238_
+ sky130_fd_sc_hd__a32o_1
X_2177_ _0380_ _0384_ _0386_ TX.baud_counter\[10\] _0387_ VGND VGND VPWR VPWR _0388_
+ sky130_fd_sc_hd__o221a_1
XFILLER_0_9_6 VGND VGND VPWR VPWR sky130_fd_sc_hd__decap_6
Xinput103 S_AXI_WSTRB[1] VGND VGND VPWR VPWR net103 sky130_fd_sc_hd__dlymetal6s2s_1
XTAP_139 VGND VPWR sky130_fd_sc_hd__tapvpwrvgnd_1
XTAP_128 VGND VPWR sky130_fd_sc_hd__tapvpwrvgnd_1
XTAP_117 VGND VPWR sky130_fd_sc_hd__tapvpwrvgnd_1
X_3080_ _0959_ _1160_ VGND VGND VPWR VPWR _1228_ sky130_fd_sc_hd__nor2_1
X_2100_ net273 _0310_ VGND VGND VPWR VPWR _0320_ sky130_fd_sc_hd__or2_1
X_2031_ _1700_ _1707_ VGND VGND VPWR VPWR _1708_ sky130_fd_sc_hd__and2_1
XFILLER_0_43_21 VGND VGND VPWR VPWR sky130_fd_sc_hd__fill_1
XFILLER_0_27_55 VGND VGND VPWR VPWR sky130_fd_sc_hd__fill_1
XPHY_0 VGND VGND VPWR VPWR sky130_fd_sc_hd__decap_3
X_2795_ _0969_ _0971_ VGND VGND VPWR VPWR _0972_ sky130_fd_sc_hd__nand2_1
X_2933_ _1106_ _1107_ _1108_ _1109_ VGND VGND VPWR VPWR _1110_ sky130_fd_sc_hd__nand4_1
X_1815_ _1534_ net271 _1524_ _1544_ VGND VGND VPWR VPWR _0012_ sky130_fd_sc_hd__o211a_1
X_2864_ _1039_ _1040_ VGND VGND VPWR VPWR _1041_ sky130_fd_sc_hd__nand2_1
X_3416_ _0307_ _0494_ VGND VGND VPWR VPWR _1449_ sky130_fd_sc_hd__or2_1
X_1746_ net218 _1483_ VGND VGND VPWR VPWR _1487_ sky130_fd_sc_hd__or2_1
XFILLER_0_7_54 VGND VGND VPWR VPWR sky130_fd_sc_hd__fill_2
XFILLER_0_7_87 VGND VGND VPWR VPWR sky130_fd_sc_hd__fill_1
X_3278_ _1348_ VGND VGND VPWR VPWR _1350_ sky130_fd_sc_hd__buf_2
X_3347_ _1343_ VGND VGND VPWR VPWR _1403_ sky130_fd_sc_hd__buf_2
X_2229_ TX.baud_counter\[25\] _0434_ _0439_ TX.baud_counter\[26\] VGND VGND VPWR VPWR
+ _0440_ sky130_fd_sc_hd__o22a_1
XFILLER_0_31_220 VGND VGND VPWR VPWR sky130_fd_sc_hd__fill_1
XFILLER_0_31_297 VGND VGND VPWR VPWR sky130_fd_sc_hd__fill_1
XFILLER_0_7_3 VGND VGND VPWR VPWR sky130_fd_sc_hd__decap_8
XFILLER_0_54_345 VPWR VGND VPWR VGND sky130_ef_sc_hd__decap_12
X_2580_ _0738_ _0746_ _0754_ VGND VGND VPWR VPWR _0769_ sky130_fd_sc_hd__a21o_1
XFILLER_0_1_136 VGND VGND VPWR VPWR sky130_fd_sc_hd__fill_2
X_3201_ _0295_ VGND VGND VPWR VPWR _1302_ sky130_fd_sc_hd__clkbuf_4
X_3132_ net107 net312 _1240_ VGND VGND VPWR VPWR _1265_ sky130_fd_sc_hd__mux2_1
X_3063_ _1153_ _1214_ VGND VGND VPWR VPWR _1216_ sky130_fd_sc_hd__and2b_1
X_2014_ _1690_ RX.rx_shifter\[20\] _1695_ uart_rdr\[20\] VGND VGND VPWR VPWR _1696_
+ sky130_fd_sc_hd__a22o_1
Xhold110 RX.uart_stp\[16\] VGND VGND VPWR VPWR net277 sky130_fd_sc_hd__dlygate4sd3_1
X_2847_ _0303_ RX.baud_cnt\[5\] _1016_ _1545_ VGND VGND VPWR VPWR _1024_ sky130_fd_sc_hd__a2bb2o_1
X_2778_ RX.baud_cnt\[24\] _0430_ _0946_ _0954_ VGND VGND VPWR VPWR _0955_ sky130_fd_sc_hd__a22o_1
X_2916_ _1089_ _1092_ _1076_ VGND VGND VPWR VPWR _1093_ sky130_fd_sc_hd__o21ba_1
Xhold154 net126 VGND VGND VPWR VPWR net321 sky130_fd_sc_hd__dlygate4sd3_1
X_1729_ _1467_ _1468_ _1469_ _1470_ VGND VGND VPWR VPWR _1471_ sky130_fd_sc_hd__or4_1
Xhold132 _1441_ VGND VGND VPWR VPWR net299 sky130_fd_sc_hd__dlygate4sd3_1
Xhold121 RX.baud_cnt\[2\] VGND VGND VPWR VPWR net288 sky130_fd_sc_hd__dlygate4sd3_1
Xhold143 TX.baud_counter\[15\] VGND VGND VPWR VPWR net310 sky130_fd_sc_hd__dlygate4sd3_1
XTAP_470 VGND VPWR sky130_fd_sc_hd__tapvpwrvgnd_1
XFILLER_0_48_194 VGND VGND VPWR VPWR sky130_fd_sc_hd__fill_2
XFILLER_0_24_89 VGND VGND VPWR VPWR sky130_fd_sc_hd__fill_1
X_2701_ net255 _0884_ VGND VGND VPWR VPWR _0886_ sky130_fd_sc_hd__or2_1
XFILLER_0_27_334 VGND VGND VPWR VPWR sky130_fd_sc_hd__fill_2
X_3681_ clknet_leaf_20_S_AXI_ACLK _0246_ net150 VGND VGND VPWR VPWR TX.baud_counter\[12\]
+ sky130_fd_sc_hd__dfrtp_4
X_2632_ TX.baud_counter\[3\] _0808_ VGND VGND VPWR VPWR _0821_ sky130_fd_sc_hd__or2_1
X_2563_ _0740_ _0744_ _0747_ _0750_ VGND VGND VPWR VPWR _0752_ sky130_fd_sc_hd__a211oi_1
X_2494_ _0577_ _0586_ _0681_ _0682_ VGND VGND VPWR VPWR _0683_ sky130_fd_sc_hd__a31o_1
X_3115_ _1253_ VGND VGND VPWR VPWR _0168_ sky130_fd_sc_hd__clkbuf_1
X_3046_ _0902_ _1202_ VGND VGND VPWR VPWR _1204_ sky130_fd_sc_hd__nand2_1
XFILLER_0_36_197 VGND VGND VPWR VPWR sky130_fd_sc_hd__fill_1
X_1994_ _1667_ RX.rx_shifter\[14\] _1672_ uart_rdr\[14\] VGND VGND VPWR VPWR _1682_
+ sky130_fd_sc_hd__a22o_1
XFILLER_0_51_65 VGND VGND VPWR VPWR sky130_fd_sc_hd__fill_2
XFILLER_0_51_21 VGND VGND VPWR VPWR sky130_fd_sc_hd__fill_1
X_3664_ clknet_leaf_3_S_AXI_ACLK _0229_ VGND VGND VPWR VPWR RX.uart_stp\[30\] sky130_fd_sc_hd__dfxtp_1
XFILLER_0_15_359 VGND VGND VPWR VPWR sky130_fd_sc_hd__fill_2
X_2615_ TX.baud_counter\[13\] _0800_ _0802_ _0803_ TX.baud_counter\[12\] VGND VGND
+ VPWR VPWR _0804_ sky130_fd_sc_hd__a32o_1
X_3595_ clknet_leaf_22_S_AXI_ACLK _0160_ net154 VGND VGND VPWR VPWR RX.baud_cnt\[28\]
+ sky130_fd_sc_hd__dfrtp_4
X_2546_ _0725_ _0729_ _0733_ _0589_ VGND VGND VPWR VPWR _0735_ sky130_fd_sc_hd__a31o_1
X_2477_ _0534_ _0537_ _0542_ VGND VGND VPWR VPWR _0666_ sky130_fd_sc_hd__nand3_1
X_3029_ RX.baud_cnt\[12\] RX.baud_cnt\[11\] _1188_ VGND VGND VPWR VPWR _1192_ sky130_fd_sc_hd__and3_1
XFILLER_0_18_131 VGND VGND VPWR VPWR sky130_fd_sc_hd__fill_1
XFILLER_0_18_186 VGND VGND VPWR VPWR sky130_fd_sc_hd__decap_3
X_2400_ _0588_ VGND VGND VPWR VPWR _0589_ sky130_fd_sc_hd__clkbuf_4
XFILLER_0_21_46 VGND VGND VPWR VPWR sky130_fd_sc_hd__decap_4
X_2331_ RX.uart_cpb\[3\] RX.uart_cpb\[2\] VGND VGND VPWR VPWR _0520_ sky130_fd_sc_hd__xnor2_2
X_3380_ _1425_ _1426_ VGND VGND VPWR VPWR _1427_ sky130_fd_sc_hd__nor2_1
X_2262_ TX.state\[0\] _0471_ _0472_ _0468_ VGND VGND VPWR VPWR _0473_ sky130_fd_sc_hd__o211ai_2
X_2193_ RX.uart_cpb\[15\] VGND VGND VPWR VPWR _0404_ sky130_fd_sc_hd__inv_2
X_1977_ _1667_ RX.rx_shifter\[9\] _1649_ uart_rdr\[9\] VGND VGND VPWR VPWR _1670_
+ sky130_fd_sc_hd__a22o_1
X_3716_ clknet_leaf_6_S_AXI_ACLK _0281_ VGND VGND VPWR VPWR RX.uart_stp\[15\] sky130_fd_sc_hd__dfxtp_1
XFILLER_0_7_334 VGND VGND VPWR VPWR sky130_fd_sc_hd__fill_2
X_3647_ clknet_leaf_0_S_AXI_ACLK _0212_ VGND VGND VPWR VPWR RX.uart_cpb\[21\] sky130_fd_sc_hd__dfxtp_2
X_2529_ _0715_ _0716_ _0717_ VGND VGND VPWR VPWR _0718_ sky130_fd_sc_hd__a21oi_1
XFILLER_0_30_104 VGND VGND VPWR VPWR sky130_fd_sc_hd__decap_8
X_3578_ clknet_leaf_16_S_AXI_ACLK _0143_ net158 VGND VGND VPWR VPWR RX.baud_cnt\[11\]
+ sky130_fd_sc_hd__dfrtp_4
Xhold47 RX.rx_shifter\[22\] VGND VGND VPWR VPWR net214 sky130_fd_sc_hd__dlygate4sd3_1
Xhold36 RX.uart_stp\[13\] VGND VGND VPWR VPWR net203 sky130_fd_sc_hd__dlygate4sd3_1
Xhold69 TX.uart_tdr\[19\] VGND VGND VPWR VPWR net236 sky130_fd_sc_hd__dlygate4sd3_1
Xhold58 RX.uart_stp\[21\] VGND VGND VPWR VPWR net225 sky130_fd_sc_hd__dlygate4sd3_1
Xhold14 RX.rx_shifter\[6\] VGND VGND VPWR VPWR net181 sky130_fd_sc_hd__dlygate4sd3_1
Xhold25 net133 VGND VGND VPWR VPWR net192 sky130_fd_sc_hd__dlygate4sd3_1
XFILLER_0_16_79 VGND VGND VPWR VPWR sky130_fd_sc_hd__decap_4
X_1900_ _1609_ net170 _1600_ _1612_ VGND VGND VPWR VPWR _0029_ sky130_fd_sc_hd__o211a_1
XFILLER_0_44_207 VGND VGND VPWR VPWR sky130_fd_sc_hd__decap_3
X_1831_ RX.uart_cpb\[8\] VGND VGND VPWR VPWR _1557_ sky130_fd_sc_hd__clkbuf_4
XFILLER_0_32_56 VGND VGND VPWR VPWR sky130_fd_sc_hd__decap_4
XFILLER_0_32_34 VGND VGND VPWR VPWR sky130_fd_sc_hd__fill_1
X_2880_ RX.state\[1\] _1051_ _1056_ RX.state\[0\] VGND VGND VPWR VPWR _1057_ sky130_fd_sc_hd__or4bb_1
XFILLER_0_4_315 VPWR VGND VPWR VGND sky130_ef_sc_hd__decap_12
X_1762_ net32 net31 net3 net2 VGND VGND VPWR VPWR _1496_ sky130_fd_sc_hd__or4_1
X_3501_ clknet_leaf_2_S_AXI_ACLK _0066_ VGND VGND VPWR VPWR uart_rdr\[26\] sky130_fd_sc_hd__dfxtp_1
X_3432_ net75 _1450_ _1458_ _1336_ VGND VGND VPWR VPWR _0280_ sky130_fd_sc_hd__o211a_1
X_3363_ _1364_ _1412_ _1414_ _1403_ TX.baud_counter\[21\] VGND VGND VPWR VPWR _0255_
+ sky130_fd_sc_hd__a32o_1
XFILLER_0_57_42 VGND VGND VPWR VPWR sky130_fd_sc_hd__decap_3
X_2314_ net242 _0497_ VGND VGND VPWR VPWR _0505_ sky130_fd_sc_hd__or2_1
X_2245_ _0455_ _0443_ VGND VGND VPWR VPWR _0456_ sky130_fd_sc_hd__xnor2_2
X_3294_ TX.baud_counter\[4\] _1360_ _1353_ VGND VGND VPWR VPWR _1363_ sky130_fd_sc_hd__a21oi_1
X_2176_ TX.baud_counter\[9\] _0383_ VGND VGND VPWR VPWR _0387_ sky130_fd_sc_hd__or2_1
Xinput104 S_AXI_WSTRB[2] VGND VGND VPWR VPWR net104 sky130_fd_sc_hd__clkbuf_1
XPHY_110 VGND VGND VPWR VPWR sky130_fd_sc_hd__decap_3
XFILLER_0_34_251 VGND VGND VPWR VPWR sky130_fd_sc_hd__fill_1
X_2030_ _1690_ RX.rx_shifter\[25\] _1695_ uart_rdr\[25\] VGND VGND VPWR VPWR _1707_
+ sky130_fd_sc_hd__a22o_1
XTAP_118 VGND VPWR sky130_fd_sc_hd__tapvpwrvgnd_1
XTAP_129 VGND VPWR sky130_fd_sc_hd__tapvpwrvgnd_1
XFILLER_0_57_343 VGND VGND VPWR VPWR sky130_fd_sc_hd__decap_3
XPHY_1 VGND VGND VPWR VPWR sky130_fd_sc_hd__decap_3
X_2932_ RX.baud_cnt\[20\] _0783_ VGND VGND VPWR VPWR _1109_ sky130_fd_sc_hd__nand2_1
X_1745_ net86 _1482_ _1484_ _1486_ VGND VGND VPWR VPWR _0000_ sky130_fd_sc_hd__o211a_1
X_2794_ RX.bit_idx\[2\] RX.bit_idx\[1\] _0970_ VGND VGND VPWR VPWR _0971_ sky130_fd_sc_hd__and3_1
X_1814_ _1541_ _1536_ _1542_ _1543_ VGND VGND VPWR VPWR _1544_ sky130_fd_sc_hd__a211o_1
X_2863_ RX.uart_cpb\[13\] _1037_ _1030_ RX.uart_cpb\[12\] VGND VGND VPWR VPWR _1040_
+ sky130_fd_sc_hd__o22a_1
X_3346_ _1400_ _1401_ VGND VGND VPWR VPWR _1402_ sky130_fd_sc_hd__nor2_1
X_3415_ _1448_ VGND VGND VPWR VPWR _0273_ sky130_fd_sc_hd__clkbuf_1
X_2159_ TX.baud_counter\[4\] _0359_ VGND VGND VPWR VPWR _0370_ sky130_fd_sc_hd__or2_1
X_3277_ _1349_ VGND VGND VPWR VPWR _0234_ sky130_fd_sc_hd__clkbuf_1
X_2228_ _0437_ _0438_ VGND VGND VPWR VPWR _0439_ sky130_fd_sc_hd__nor2_1
XFILLER_0_39_310 VGND VGND VPWR VPWR sky130_fd_sc_hd__fill_1
XFILLER_0_54_357 VGND VGND VPWR VPWR sky130_fd_sc_hd__decap_6
X_3200_ _0449_ _1291_ VGND VGND VPWR VPWR _1301_ sky130_fd_sc_hd__nand2_1
XFILLER_0_54_21 VGND VGND VPWR VPWR sky130_fd_sc_hd__decap_6
X_2013_ _1648_ VGND VGND VPWR VPWR _1695_ sky130_fd_sc_hd__clkbuf_4
X_3131_ net181 _1263_ _1264_ _1249_ VGND VGND VPWR VPWR _0173_ sky130_fd_sc_hd__a22o_1
X_3062_ _1194_ _1213_ _1215_ _1186_ RX.baud_cnt\[21\] VGND VGND VPWR VPWR _0153_ sky130_fd_sc_hd__a32o_1
XFILLER_0_57_195 VGND VGND VPWR VPWR sky130_fd_sc_hd__fill_1
X_2915_ _0910_ _0805_ _1077_ _1091_ _1084_ VGND VGND VPWR VPWR _1092_ sky130_fd_sc_hd__o221a_1
Xhold100 TX.uart_tdr\[11\] VGND VGND VPWR VPWR net267 sky130_fd_sc_hd__dlygate4sd3_1
Xhold133 RX.uart_stp\[23\] VGND VGND VPWR VPWR net300 sky130_fd_sc_hd__dlygate4sd3_1
Xhold144 TX.data_latch_next\[1\] VGND VGND VPWR VPWR net311 sky130_fd_sc_hd__dlygate4sd3_1
Xhold111 RX.baud_cnt\[30\] VGND VGND VPWR VPWR net278 sky130_fd_sc_hd__dlygate4sd3_1
X_2846_ _1019_ _1021_ _1022_ VGND VGND VPWR VPWR _1023_ sky130_fd_sc_hd__a21oi_1
Xhold122 RX.uart_stp\[5\] VGND VGND VPWR VPWR net289 sky130_fd_sc_hd__dlygate4sd3_1
X_2777_ _0937_ _0918_ _0953_ VGND VGND VPWR VPWR _0954_ sky130_fd_sc_hd__and3_1
X_1728_ net56 net55 net59 net58 VGND VGND VPWR VPWR _1470_ sky130_fd_sc_hd__or4_2
XTAP_471 VGND VPWR sky130_fd_sc_hd__tapvpwrvgnd_1
XTAP_460 VGND VPWR sky130_fd_sc_hd__tapvpwrvgnd_1
X_3329_ _1369_ _1387_ _1389_ _1368_ TX.baud_counter\[12\] VGND VGND VPWR VPWR _0246_
+ sky130_fd_sc_hd__a32o_1
Xhold155 TX.data_latch\[7\] VGND VGND VPWR VPWR net322 sky130_fd_sc_hd__dlygate4sd3_1
XFILLER_0_13_287 VGND VGND VPWR VPWR sky130_fd_sc_hd__fill_1
X_2700_ net77 _0883_ _0885_ _0502_ VGND VGND VPWR VPWR _0121_ sky130_fd_sc_hd__o211a_1
X_2562_ _0747_ _0750_ _0740_ _0744_ VGND VGND VPWR VPWR _0751_ sky130_fd_sc_hd__o211a_1
X_2631_ _0639_ _0819_ VGND VGND VPWR VPWR _0820_ sky130_fd_sc_hd__nor2_1
X_3680_ clknet_leaf_19_S_AXI_ACLK _0245_ net153 VGND VGND VPWR VPWR TX.baud_counter\[11\]
+ sky130_fd_sc_hd__dfrtp_2
X_2493_ RX.uart_cpb\[17\] _1526_ _0582_ _1596_ VGND VGND VPWR VPWR _0682_ sky130_fd_sc_hd__a22o_1
XFILLER_0_10_257 VGND VGND VPWR VPWR sky130_fd_sc_hd__fill_1
X_3114_ net107 net314 _1252_ VGND VGND VPWR VPWR _1253_ sky130_fd_sc_hd__mux2_1
X_3045_ _1194_ _1201_ _1203_ _1186_ RX.baud_cnt\[16\] VGND VGND VPWR VPWR _0148_ sky130_fd_sc_hd__a32o_1
XFILLER_0_45_121 VGND VGND VPWR VPWR sky130_fd_sc_hd__fill_2
X_2829_ _0350_ RX.baud_cnt\[20\] _0904_ _0352_ _1005_ VGND VGND VPWR VPWR _1006_ sky130_fd_sc_hd__a221o_1
XTAP_290 VGND VPWR sky130_fd_sc_hd__tapvpwrvgnd_1
XFILLER_0_36_132 VGND VGND VPWR VPWR sky130_fd_sc_hd__fill_2
X_1993_ _1681_ VGND VGND VPWR VPWR _0053_ sky130_fd_sc_hd__clkbuf_1
X_3663_ clknet_leaf_3_S_AXI_ACLK _0228_ VGND VGND VPWR VPWR RX.uart_stp\[29\] sky130_fd_sc_hd__dfxtp_1
X_2545_ _0725_ _0729_ _0733_ VGND VGND VPWR VPWR _0734_ sky130_fd_sc_hd__a21oi_1
X_2614_ _0660_ _0668_ VGND VGND VPWR VPWR _0803_ sky130_fd_sc_hd__xnor2_2
X_3594_ clknet_leaf_22_S_AXI_ACLK _0159_ net154 VGND VGND VPWR VPWR RX.baud_cnt\[27\]
+ sky130_fd_sc_hd__dfrtp_1
X_2476_ _0576_ _0662_ _0663_ _0664_ VGND VGND VPWR VPWR _0665_ sky130_fd_sc_hd__a31o_1
X_3028_ RX.baud_cnt\[11\] _1188_ RX.baud_cnt\[12\] VGND VGND VPWR VPWR _1191_ sky130_fd_sc_hd__a21o_1
XFILLER_0_33_113 VGND VGND VPWR VPWR sky130_fd_sc_hd__decap_4
XFILLER_0_24_168 VGND VGND VPWR VPWR sky130_fd_sc_hd__fill_1
X_2192_ RX.uart_cpb\[14\] VGND VGND VPWR VPWR _0403_ sky130_fd_sc_hd__inv_2
X_2330_ RX.uart_cpb\[4\] RX.uart_cpb\[3\] VGND VGND VPWR VPWR _0519_ sky130_fd_sc_hd__nor2_2
X_2261_ _1465_ _1463_ VGND VGND VPWR VPWR _0472_ sky130_fd_sc_hd__nand2_1
XFILLER_0_20_363 VGND VGND VPWR VPWR sky130_fd_sc_hd__fill_1
XFILLER_0_1_13 VPWR VGND VPWR VGND sky130_ef_sc_hd__decap_12
XFILLER_0_1_57 VPWR VGND VPWR VGND sky130_ef_sc_hd__decap_12
X_1976_ _1669_ VGND VGND VPWR VPWR _0048_ sky130_fd_sc_hd__clkbuf_1
X_3715_ clknet_leaf_8_S_AXI_ACLK _0280_ VGND VGND VPWR VPWR RX.uart_stp\[14\] sky130_fd_sc_hd__dfxtp_1
XFILLER_0_15_113 VGND VGND VPWR VPWR sky130_fd_sc_hd__fill_1
X_3646_ clknet_leaf_0_S_AXI_ACLK _0211_ VGND VGND VPWR VPWR RX.uart_cpb\[20\] sky130_fd_sc_hd__dfxtp_2
X_2528_ _0706_ _0711_ VGND VGND VPWR VPWR _0717_ sky130_fd_sc_hd__nand2_1
XFILLER_0_30_149 VGND VGND VPWR VPWR sky130_fd_sc_hd__decap_3
XFILLER_0_30_116 VGND VGND VPWR VPWR sky130_fd_sc_hd__fill_2
X_3577_ clknet_leaf_16_S_AXI_ACLK _0142_ net158 VGND VGND VPWR VPWR RX.baud_cnt\[10\]
+ sky130_fd_sc_hd__dfrtp_4
Xhold48 RX.rx_shifter\[21\] VGND VGND VPWR VPWR net215 sky130_fd_sc_hd__dlygate4sd3_1
Xhold59 RX.uart_stp\[10\] VGND VGND VPWR VPWR net226 sky130_fd_sc_hd__dlygate4sd3_1
Xhold37 net128 VGND VGND VPWR VPWR net204 sky130_fd_sc_hd__dlygate4sd3_1
Xhold15 uart_cfg\[1\] VGND VGND VPWR VPWR net182 sky130_fd_sc_hd__dlygate4sd3_1
Xhold26 _0010_ VGND VGND VPWR VPWR net193 sky130_fd_sc_hd__dlygate4sd3_1
X_2459_ _0606_ _0640_ _0644_ _0647_ VGND VGND VPWR VPWR _0648_ sky130_fd_sc_hd__and4b_2
XFILLER_0_16_47 VGND VGND VPWR VPWR sky130_fd_sc_hd__fill_2
X_3500_ clknet_leaf_2_S_AXI_ACLK _0065_ VGND VGND VPWR VPWR uart_rdr\[25\] sky130_fd_sc_hd__dfxtp_1
X_1761_ _1494_ VGND VGND VPWR VPWR _1495_ sky130_fd_sc_hd__clkbuf_4
XFILLER_0_4_327 VPWR VGND VPWR VGND sky130_ef_sc_hd__decap_12
X_1830_ _1534_ net180 _1524_ _1556_ VGND VGND VPWR VPWR _0015_ sky130_fd_sc_hd__o211a_1
X_3431_ net237 _1451_ VGND VGND VPWR VPWR _1458_ sky130_fd_sc_hd__or2_1
X_2313_ net74 _0496_ _0504_ _0502_ VGND VGND VPWR VPWR _0115_ sky130_fd_sc_hd__o211a_1
X_3362_ _1381_ _1413_ VGND VGND VPWR VPWR _1414_ sky130_fd_sc_hd__nor2_1
X_2244_ RX.uart_cpb\[28\] VGND VGND VPWR VPWR _0455_ sky130_fd_sc_hd__inv_2
X_3293_ TX.baud_counter\[4\] _1360_ VGND VGND VPWR VPWR _1362_ sky130_fd_sc_hd__or2_1
X_2175_ _0385_ _0381_ VGND VGND VPWR VPWR _0386_ sky130_fd_sc_hd__xnor2_2
XFILLER_0_35_208 VGND VGND VPWR VPWR sky130_fd_sc_hd__fill_2
XFILLER_0_7_121 VGND VGND VPWR VPWR sky130_fd_sc_hd__fill_1
X_3629_ clknet_leaf_3_S_AXI_ACLK _0194_ net155 VGND VGND VPWR VPWR RX.rx_shifter\[27\]
+ sky130_fd_sc_hd__dfrtp_1
X_1959_ _1654_ _1657_ VGND VGND VPWR VPWR _1658_ sky130_fd_sc_hd__and2_1
Xinput105 S_AXI_WSTRB[3] VGND VGND VPWR VPWR net105 sky130_fd_sc_hd__dlymetal6s2s_1
XPHY_100 VGND VGND VPWR VPWR sky130_fd_sc_hd__decap_3
XPHY_111 VGND VGND VPWR VPWR sky130_fd_sc_hd__decap_3
XTAP_119 VGND VPWR sky130_fd_sc_hd__tapvpwrvgnd_1
XFILLER_0_27_57 VGND VGND VPWR VPWR sky130_fd_sc_hd__fill_1
X_2931_ _0995_ _0704_ _0785_ VGND VGND VPWR VPWR _1108_ sky130_fd_sc_hd__or3_1
XPHY_2 VGND VGND VPWR VPWR sky130_fd_sc_hd__decap_3
X_2793_ RX.bit_idx\[0\] VGND VGND VPWR VPWR _0970_ sky130_fd_sc_hd__buf_2
X_1744_ _1485_ VGND VGND VPWR VPWR _1486_ sky130_fd_sc_hd__clkbuf_4
X_1813_ uart_rdr\[4\] _1538_ _1495_ VGND VGND VPWR VPWR _1543_ sky130_fd_sc_hd__a21bo_1
X_2862_ _0408_ _0936_ RX.baud_cnt\[14\] _0404_ VGND VGND VPWR VPWR _1039_ sky130_fd_sc_hd__o22a_1
X_3276_ _1348_ _1343_ TX.baud_counter\[0\] VGND VGND VPWR VPWR _1349_ sky130_fd_sc_hd__mux2_1
XFILLER_0_0_352 VGND VGND VPWR VPWR sky130_fd_sc_hd__fill_2
X_3345_ TX.baud_counter\[17\] TX.baud_counter\[16\] _1396_ VGND VGND VPWR VPWR _1401_
+ sky130_fd_sc_hd__and3_1
X_3414_ TX.data_latch_next\[7\] net322 _1440_ VGND VGND VPWR VPWR _1448_ sky130_fd_sc_hd__mux2_1
X_2089_ net81 _0309_ _0314_ _0296_ VGND VGND VPWR VPWR _0081_ sky130_fd_sc_hd__o211a_1
X_2227_ _1625_ _0432_ VGND VGND VPWR VPWR _0438_ sky130_fd_sc_hd__and2_1
X_2158_ TX.baud_counter\[3\] _0362_ _0367_ TX.baud_counter\[2\] VGND VGND VPWR VPWR
+ _0369_ sky130_fd_sc_hd__a22o_1
XFILLER_0_23_3 VGND VGND VPWR VPWR sky130_fd_sc_hd__decap_4
XFILLER_0_38_56 VGND VGND VPWR VPWR sky130_fd_sc_hd__fill_2
X_3130_ _0970_ net107 RX.bit_idx\[2\] RX.bit_idx\[1\] VGND VGND VPWR VPWR _1264_ sky130_fd_sc_hd__and4b_1
X_2012_ _1694_ VGND VGND VPWR VPWR _0059_ sky130_fd_sc_hd__clkbuf_1
XFILLER_0_54_66 VGND VGND VPWR VPWR sky130_fd_sc_hd__fill_1
X_3061_ _0974_ _1214_ VGND VGND VPWR VPWR _1215_ sky130_fd_sc_hd__nor2_1
XFILLER_0_45_314 VGND VGND VPWR VPWR sky130_fd_sc_hd__fill_2
X_2845_ _0300_ _0922_ _1018_ _1535_ VGND VGND VPWR VPWR _1022_ sky130_fd_sc_hd__a2bb2o_1
X_2914_ RX.baud_cnt\[11\] _0840_ _1080_ _1081_ _1078_ VGND VGND VPWR VPWR _1091_ sky130_fd_sc_hd__o221a_1
Xhold134 RX.rx_shifter\[16\] VGND VGND VPWR VPWR net301 sky130_fd_sc_hd__dlygate4sd3_1
X_1727_ net52 net51 net54 net53 VGND VGND VPWR VPWR _1469_ sky130_fd_sc_hd__or4_1
Xhold101 RX.uart_stp\[28\] VGND VGND VPWR VPWR net268 sky130_fd_sc_hd__dlygate4sd3_1
Xhold145 RX.rx_shifter\[7\] VGND VGND VPWR VPWR net312 sky130_fd_sc_hd__dlygate4sd3_1
Xhold112 _0163_ VGND VGND VPWR VPWR net279 sky130_fd_sc_hd__dlygate4sd3_1
Xhold156 TX.data_latch\[4\] VGND VGND VPWR VPWR net323 sky130_fd_sc_hd__dlygate4sd3_1
X_2776_ _0911_ _0933_ _0939_ _0952_ VGND VGND VPWR VPWR _0953_ sky130_fd_sc_hd__and4_1
Xhold123 TX.data_latch\[2\] VGND VGND VPWR VPWR net290 sky130_fd_sc_hd__dlygate4sd3_1
XTAP_472 VGND VPWR sky130_fd_sc_hd__tapvpwrvgnd_1
XTAP_461 VGND VPWR sky130_fd_sc_hd__tapvpwrvgnd_1
XTAP_450 VGND VPWR sky130_fd_sc_hd__tapvpwrvgnd_1
X_3259_ net252 _1329_ VGND VGND VPWR VPWR _1337_ sky130_fd_sc_hd__or2_1
X_3328_ _1353_ _1388_ VGND VGND VPWR VPWR _1389_ sky130_fd_sc_hd__nor2_1
XFILLER_0_48_141 VGND VGND VPWR VPWR sky130_fd_sc_hd__fill_2
XFILLER_0_36_347 VGND VGND VPWR VPWR sky130_fd_sc_hd__fill_1
XFILLER_0_49_44 VGND VGND VPWR VPWR sky130_fd_sc_hd__decap_4
X_2561_ _0748_ _0749_ VGND VGND VPWR VPWR _0750_ sky130_fd_sc_hd__nor2_1
X_2492_ _0556_ _0561_ _0585_ VGND VGND VPWR VPWR _0681_ sky130_fd_sc_hd__nand3_1
X_2630_ _0629_ _0635_ _0638_ VGND VGND VPWR VPWR _0819_ sky130_fd_sc_hd__a21oi_1
X_3113_ _1251_ RX.bit_idx\[1\] _0970_ VGND VGND VPWR VPWR _1252_ sky130_fd_sc_hd__or3b_1
XFILLER_0_10_269 VGND VGND VPWR VPWR sky130_fd_sc_hd__fill_1
X_3044_ _0974_ _1202_ VGND VGND VPWR VPWR _1203_ sky130_fd_sc_hd__nor2_1
XFILLER_0_33_317 VGND VGND VPWR VPWR sky130_fd_sc_hd__fill_1
X_2828_ _0999_ _1004_ VGND VGND VPWR VPWR _1005_ sky130_fd_sc_hd__nor2_1
XFILLER_0_18_314 VGND VGND VPWR VPWR sky130_fd_sc_hd__fill_1
X_2759_ RX.baud_cnt\[15\] VGND VGND VPWR VPWR _0936_ sky130_fd_sc_hd__buf_2
XTAP_291 VGND VPWR sky130_fd_sc_hd__tapvpwrvgnd_1
XTAP_280 VGND VPWR sky130_fd_sc_hd__tapvpwrvgnd_1
XFILLER_0_35_68 VGND VGND VPWR VPWR sky130_fd_sc_hd__fill_1
X_1992_ _1677_ _1680_ VGND VGND VPWR VPWR _1681_ sky130_fd_sc_hd__and2_1
X_3662_ clknet_leaf_4_S_AXI_ACLK _0227_ VGND VGND VPWR VPWR RX.uart_stp\[28\] sky130_fd_sc_hd__dfxtp_1
XFILLER_0_42_114 VGND VGND VPWR VPWR sky130_fd_sc_hd__fill_1
XFILLER_0_27_111 VGND VGND VPWR VPWR sky130_fd_sc_hd__fill_1
X_2544_ RX.uart_cpb\[28\] RX.uart_cpb\[27\] VGND VGND VPWR VPWR _0733_ sky130_fd_sc_hd__xnor2_1
XFILLER_0_30_309 VGND VGND VPWR VPWR sky130_fd_sc_hd__fill_1
X_2475_ RX.uart_cpb\[12\] _1525_ _0581_ RX.uart_cpb\[13\] VGND VGND VPWR VPWR _0664_
+ sky130_fd_sc_hd__a22o_1
X_2613_ _0660_ _0801_ _0665_ VGND VGND VPWR VPWR _0802_ sky130_fd_sc_hd__a21bo_1
X_3593_ clknet_leaf_22_S_AXI_ACLK _0158_ net154 VGND VGND VPWR VPWR RX.baud_cnt\[26\]
+ sky130_fd_sc_hd__dfrtp_4
X_3027_ _1159_ _1188_ _1190_ _1189_ RX.baud_cnt\[11\] VGND VGND VPWR VPWR _0143_ sky130_fd_sc_hd__a32o_1
XFILLER_0_33_169 VGND VGND VPWR VPWR sky130_fd_sc_hd__decap_4
XFILLER_0_14_361 VGND VGND VPWR VPWR sky130_fd_sc_hd__decap_3
XFILLER_0_12_309 VGND VGND VPWR VPWR sky130_fd_sc_hd__fill_1
X_2260_ TX.bit_index\[2\] _0470_ VGND VGND VPWR VPWR _0471_ sky130_fd_sc_hd__nand2_1
X_2191_ _0395_ _0399_ _0400_ TX.baud_counter\[14\] _0401_ VGND VGND VPWR VPWR _0402_
+ sky130_fd_sc_hd__o221a_1
XFILLER_0_1_25 VPWR VGND VPWR VGND sky130_ef_sc_hd__decap_12
XFILLER_0_1_69 VGND VGND VPWR VPWR sky130_fd_sc_hd__decap_4
X_3714_ clknet_leaf_7_S_AXI_ACLK _0279_ VGND VGND VPWR VPWR RX.uart_stp\[13\] sky130_fd_sc_hd__dfxtp_1
X_1975_ _1654_ _1668_ VGND VGND VPWR VPWR _1669_ sky130_fd_sc_hd__and2_1
X_3645_ clknet_leaf_0_S_AXI_ACLK _0210_ VGND VGND VPWR VPWR RX.uart_cpb\[19\] sky130_fd_sc_hd__dfxtp_2
XFILLER_0_15_103 VGND VGND VPWR VPWR sky130_fd_sc_hd__decap_6
XFILLER_0_15_169 VGND VGND VPWR VPWR sky130_fd_sc_hd__fill_2
XFILLER_0_53_3 VGND VGND VPWR VPWR sky130_fd_sc_hd__decap_8
Xhold27 TX.uart_tdr\[15\] VGND VGND VPWR VPWR net194 sky130_fd_sc_hd__dlygate4sd3_1
Xhold16 net116 VGND VGND VPWR VPWR net183 sky130_fd_sc_hd__dlygate4sd3_1
Xhold38 TX.uart_tdr\[21\] VGND VGND VPWR VPWR net205 sky130_fd_sc_hd__dlygate4sd3_1
X_2527_ _1625_ RX.uart_cpb\[25\] VGND VGND VPWR VPWR _0716_ sky130_fd_sc_hd__nand2_1
XFILLER_0_30_139 VGND VGND VPWR VPWR sky130_fd_sc_hd__fill_1
X_3576_ clknet_leaf_16_S_AXI_ACLK _0141_ net158 VGND VGND VPWR VPWR RX.baud_cnt\[9\]
+ sky130_fd_sc_hd__dfrtp_4
X_2458_ _0600_ _0576_ _0645_ _0646_ VGND VGND VPWR VPWR _0647_ sky130_fd_sc_hd__a31oi_2
Xhold49 RX.rx_shifter\[24\] VGND VGND VPWR VPWR net216 sky130_fd_sc_hd__dlygate4sd3_1
X_2389_ _0573_ _0508_ _0570_ VGND VGND VPWR VPWR _0578_ sky130_fd_sc_hd__or3_1
X_1760_ net108 VGND VGND VPWR VPWR _1494_ sky130_fd_sc_hd__buf_2
XFILLER_0_4_339 VPWR VGND VPWR VGND sky130_ef_sc_hd__decap_12
XFILLER_0_12_106 VGND VGND VPWR VPWR sky130_fd_sc_hd__fill_2
X_2312_ net206 _0497_ VGND VGND VPWR VPWR _0504_ sky130_fd_sc_hd__or2_1
X_3430_ net74 _1450_ _1457_ _1336_ VGND VGND VPWR VPWR _0279_ sky130_fd_sc_hd__o211a_1
X_3292_ _1350_ _1359_ _1361_ _1355_ net244 VGND VGND VPWR VPWR _0237_ sky130_fd_sc_hd__a32o_1
X_3361_ TX.baud_counter\[21\] _1410_ VGND VGND VPWR VPWR _1413_ sky130_fd_sc_hd__and2_1
XFILLER_0_12_139 VGND VGND VPWR VPWR sky130_fd_sc_hd__fill_1
XFILLER_0_20_172 VGND VGND VPWR VPWR sky130_fd_sc_hd__fill_2
XFILLER_0_20_194 VGND VGND VPWR VPWR sky130_fd_sc_hd__fill_2
X_2174_ RX.uart_cpb\[10\] VGND VGND VPWR VPWR _0385_ sky130_fd_sc_hd__inv_2
X_2243_ TX.baud_counter\[31\] _0451_ _0453_ TX.baud_counter\[30\] VGND VGND VPWR VPWR
+ _0454_ sky130_fd_sc_hd__a22o_1
XFILLER_0_7_111 VGND VGND VPWR VPWR sky130_fd_sc_hd__fill_1
X_3628_ clknet_leaf_2_S_AXI_ACLK _0193_ net155 VGND VGND VPWR VPWR RX.rx_shifter\[26\]
+ sky130_fd_sc_hd__dfrtp_1
X_1889_ _1571_ net293 _1600_ _1603_ VGND VGND VPWR VPWR _0027_ sky130_fd_sc_hd__o211a_1
X_1958_ _1646_ RX.rx_shifter\[3\] _1649_ uart_rdr\[3\] VGND VGND VPWR VPWR _1657_
+ sky130_fd_sc_hd__a22o_1
X_3559_ clknet_leaf_0_S_AXI_ACLK _0124_ VGND VGND VPWR VPWR RX.uart_stp\[19\] sky130_fd_sc_hd__dfxtp_1
Xinput106 S_AXI_WVALID VGND VGND VPWR VPWR net106 sky130_fd_sc_hd__clkbuf_1
XPHY_112 VGND VGND VPWR VPWR sky130_fd_sc_hd__decap_3
XPHY_101 VGND VGND VPWR VPWR sky130_fd_sc_hd__decap_3
XFILLER_0_34_264 VGND VGND VPWR VPWR sky130_fd_sc_hd__fill_2
XFILLER_0_27_69 VGND VGND VPWR VPWR sky130_fd_sc_hd__fill_1
XFILLER_0_43_46 VGND VGND VPWR VPWR sky130_fd_sc_hd__fill_2
X_2930_ RX.baud_cnt\[20\] _0783_ VGND VGND VPWR VPWR _1107_ sky130_fd_sc_hd__or2_1
XPHY_3 VGND VGND VPWR VPWR sky130_fd_sc_hd__decap_3
X_2861_ _0403_ _0910_ _1037_ RX.uart_cpb\[13\] VGND VGND VPWR VPWR _1038_ sky130_fd_sc_hd__a2bb2o_1
X_1743_ net156 VGND VGND VPWR VPWR _1485_ sky130_fd_sc_hd__buf_4
XFILLER_0_40_223 VGND VGND VPWR VPWR sky130_fd_sc_hd__fill_1
X_2792_ _0966_ _0967_ _0968_ VGND VGND VPWR VPWR _0969_ sky130_fd_sc_hd__o21a_1
XFILLER_0_4_169 VGND VGND VPWR VPWR sky130_fd_sc_hd__fill_1
XFILLER_0_7_57 VGND VGND VPWR VPWR sky130_fd_sc_hd__fill_2
X_3413_ _1447_ VGND VGND VPWR VPWR _0272_ sky130_fd_sc_hd__clkbuf_1
X_1812_ TX.data_latch_next\[4\] _1507_ _1509_ RX.uart_stp\[4\] VGND VGND VPWR VPWR
+ _1542_ sky130_fd_sc_hd__a22o_1
X_2226_ _1625_ _0432_ VGND VGND VPWR VPWR _0437_ sky130_fd_sc_hd__nor2_1
X_3344_ TX.baud_counter\[16\] _1396_ TX.baud_counter\[17\] VGND VGND VPWR VPWR _1400_
+ sky130_fd_sc_hd__a21oi_1
X_3275_ _0468_ _1339_ _0872_ _1345_ VGND VGND VPWR VPWR _1348_ sky130_fd_sc_hd__a2bb2o_2
X_2157_ _0364_ _0365_ _0367_ TX.baud_counter\[2\] VGND VGND VPWR VPWR _0368_ sky130_fd_sc_hd__o22a_1
XFILLER_0_16_3 VGND VGND VPWR VPWR sky130_fd_sc_hd__fill_2
X_2088_ _0313_ _0309_ VGND VGND VPWR VPWR _0314_ sky130_fd_sc_hd__nand2_1
X_3060_ RX.baud_cnt\[21\] _1211_ VGND VGND VPWR VPWR _1214_ sky130_fd_sc_hd__and2_1
X_2011_ _1677_ _1693_ VGND VGND VPWR VPWR _1694_ sky130_fd_sc_hd__and2_1
X_2844_ _0297_ RX.baud_cnt\[1\] _1020_ VGND VGND VPWR VPWR _1021_ sky130_fd_sc_hd__o21ai_1
X_2913_ _1086_ _1087_ _1088_ _1089_ VGND VGND VPWR VPWR _1090_ sky130_fd_sc_hd__or4_1
Xhold102 RX.uart_stp\[22\] VGND VGND VPWR VPWR net269 sky130_fd_sc_hd__dlygate4sd3_1
X_1726_ net43 net42 net45 net44 VGND VGND VPWR VPWR _1468_ sky130_fd_sc_hd__or4_1
Xhold113 RX.uart_stp\[25\] VGND VGND VPWR VPWR net280 sky130_fd_sc_hd__dlygate4sd3_1
Xhold124 _1443_ VGND VGND VPWR VPWR net291 sky130_fd_sc_hd__dlygate4sd3_1
X_2775_ _0929_ _0919_ _0920_ _0951_ VGND VGND VPWR VPWR _0952_ sky130_fd_sc_hd__and4b_1
Xhold157 _1445_ VGND VGND VPWR VPWR net324 sky130_fd_sc_hd__dlygate4sd3_1
Xhold146 TX.data_latch_next\[5\] VGND VGND VPWR VPWR net313 sky130_fd_sc_hd__dlygate4sd3_1
Xhold135 RX.baud_cnt\[6\] VGND VGND VPWR VPWR net302 sky130_fd_sc_hd__dlygate4sd3_1
XTAP_473 VGND VPWR sky130_fd_sc_hd__tapvpwrvgnd_1
XTAP_462 VGND VPWR sky130_fd_sc_hd__tapvpwrvgnd_1
XTAP_451 VGND VPWR sky130_fd_sc_hd__tapvpwrvgnd_1
XTAP_440 VGND VPWR sky130_fd_sc_hd__tapvpwrvgnd_1
X_3258_ net91 _1328_ _1335_ _1336_ VGND VGND VPWR VPWR _0228_ sky130_fd_sc_hd__o211a_1
X_3189_ net88 _1625_ _1291_ VGND VGND VPWR VPWR _1295_ sky130_fd_sc_hd__mux2_1
X_2209_ _1596_ _0341_ _0342_ VGND VGND VPWR VPWR _0420_ sky130_fd_sc_hd__nor3_1
X_3327_ TX.baud_counter\[12\] _1385_ VGND VGND VPWR VPWR _1388_ sky130_fd_sc_hd__and2_1
XFILLER_0_8_250 VGND VGND VPWR VPWR sky130_fd_sc_hd__fill_2
XFILLER_0_8_283 VGND VGND VPWR VPWR sky130_fd_sc_hd__fill_2
XFILLER_0_39_175 VGND VGND VPWR VPWR sky130_fd_sc_hd__decap_3
XFILLER_0_39_164 VGND VGND VPWR VPWR sky130_fd_sc_hd__decap_4
XFILLER_0_50_362 VGND VGND VPWR VPWR sky130_fd_sc_hd__fill_2
X_2560_ RX.uart_cpb\[29\] VGND VGND VPWR VPWR _0749_ sky130_fd_sc_hd__inv_2
X_2491_ _0577_ _0677_ _0678_ _0679_ VGND VGND VPWR VPWR _0680_ sky130_fd_sc_hd__a31o_1
X_3112_ _1249_ _1250_ VGND VGND VPWR VPWR _1251_ sky130_fd_sc_hd__nand2_1
X_3043_ RX.baud_cnt\[16\] _0936_ _1198_ VGND VGND VPWR VPWR _1202_ sky130_fd_sc_hd__and3_1
X_2827_ _1001_ _1003_ VGND VGND VPWR VPWR _1004_ sky130_fd_sc_hd__and2b_1
XFILLER_0_5_253 VGND VGND VPWR VPWR sky130_fd_sc_hd__fill_1
XFILLER_0_5_275 VGND VGND VPWR VPWR sky130_fd_sc_hd__decap_4
X_2758_ _0918_ _0919_ _0931_ _0934_ VGND VGND VPWR VPWR _0935_ sky130_fd_sc_hd__a31o_1
X_2689_ _0872_ _0873_ _0877_ _0502_ VGND VGND VPWR VPWR _0118_ sky130_fd_sc_hd__o211a_1
XTAP_292 VGND VPWR sky130_fd_sc_hd__tapvpwrvgnd_1
XTAP_281 VGND VPWR sky130_fd_sc_hd__tapvpwrvgnd_1
XTAP_270 VGND VPWR sky130_fd_sc_hd__tapvpwrvgnd_1
XFILLER_0_36_167 VGND VGND VPWR VPWR sky130_fd_sc_hd__decap_3
XFILLER_0_19_48 VGND VGND VPWR VPWR sky130_fd_sc_hd__decap_3
X_1991_ _1667_ RX.rx_shifter\[13\] _1672_ uart_rdr\[13\] VGND VGND VPWR VPWR _1680_
+ sky130_fd_sc_hd__a22o_1
X_3661_ clknet_leaf_4_S_AXI_ACLK _0226_ VGND VGND VPWR VPWR RX.uart_stp\[27\] sky130_fd_sc_hd__dfxtp_1
X_2612_ _0668_ VGND VGND VPWR VPWR _0801_ sky130_fd_sc_hd__inv_2
X_3592_ clknet_leaf_21_S_AXI_ACLK _0157_ net154 VGND VGND VPWR VPWR RX.baud_cnt\[25\]
+ sky130_fd_sc_hd__dfrtp_4
XFILLER_0_55_7 VPWR VGND VPWR VGND sky130_ef_sc_hd__decap_12
XFILLER_0_48_6 VGND VGND VPWR VPWR sky130_fd_sc_hd__fill_1
X_2543_ _0723_ _0313_ _0604_ _0724_ _0731_ VGND VGND VPWR VPWR _0732_ sky130_fd_sc_hd__o221a_1
X_2474_ _0541_ _0661_ _0540_ VGND VGND VPWR VPWR _0663_ sky130_fd_sc_hd__a21o_1
X_3026_ RX.baud_cnt\[11\] _1160_ VGND VGND VPWR VPWR _1190_ sky130_fd_sc_hd__nor2_1
XFILLER_0_41_181 VGND VGND VPWR VPWR sky130_fd_sc_hd__fill_2
XFILLER_0_24_148 VGND VGND VPWR VPWR sky130_fd_sc_hd__fill_1
XFILLER_0_1_37 VPWR VGND VPWR VGND sky130_ef_sc_hd__decap_12
X_2190_ TX.baud_counter\[13\] _0398_ VGND VGND VPWR VPWR _0401_ sky130_fd_sc_hd__or2_1
X_1974_ _1667_ RX.rx_shifter\[8\] _1649_ uart_rdr\[8\] VGND VGND VPWR VPWR _1668_
+ sky130_fd_sc_hd__a22o_1
X_3713_ clknet_leaf_6_S_AXI_ACLK _0278_ VGND VGND VPWR VPWR RX.uart_stp\[12\] sky130_fd_sc_hd__dfxtp_1
X_3644_ clknet_leaf_0_S_AXI_ACLK _0209_ VGND VGND VPWR VPWR RX.uart_cpb\[18\] sky130_fd_sc_hd__dfxtp_1
X_3575_ clknet_leaf_16_S_AXI_ACLK _0140_ net158 VGND VGND VPWR VPWR RX.baud_cnt\[8\]
+ sky130_fd_sc_hd__dfrtp_4
Xhold28 RX.rx_shifter\[18\] VGND VGND VPWR VPWR net195 sky130_fd_sc_hd__dlygate4sd3_1
Xhold39 TX.uart_tdr\[13\] VGND VGND VPWR VPWR net206 sky130_fd_sc_hd__dlygate4sd3_1
Xhold17 net143 VGND VGND VPWR VPWR net184 sky130_fd_sc_hd__dlygate4sd3_1
X_2526_ _1625_ RX.uart_cpb\[25\] VGND VGND VPWR VPWR _0715_ sky130_fd_sc_hd__or2_1
X_2388_ _0576_ VGND VGND VPWR VPWR _0577_ sky130_fd_sc_hd__clkbuf_4
X_2457_ _1525_ _1553_ _0581_ RX.uart_cpb\[8\] VGND VGND VPWR VPWR _0646_ sky130_fd_sc_hd__a22o_1
X_3009_ _1176_ _1177_ _1152_ VGND VGND VPWR VPWR _1178_ sky130_fd_sc_hd__o21bai_1
XFILLER_0_32_26 VGND VGND VPWR VPWR sky130_fd_sc_hd__fill_2
XFILLER_0_4_307 VGND VGND VPWR VPWR sky130_fd_sc_hd__fill_1
XFILLER_0_57_34 VGND VGND VPWR VPWR sky130_fd_sc_hd__decap_8
X_2311_ net73 _0496_ _0503_ _0502_ VGND VGND VPWR VPWR _0114_ sky130_fd_sc_hd__o211a_1
X_2242_ _0448_ _0452_ VGND VGND VPWR VPWR _0453_ sky130_fd_sc_hd__nor2_1
X_3291_ _1353_ _1360_ VGND VGND VPWR VPWR _1361_ sky130_fd_sc_hd__nor2_1
X_3360_ TX.baud_counter\[21\] _1410_ VGND VGND VPWR VPWR _1412_ sky130_fd_sc_hd__or2_1
X_2173_ TX.baud_counter\[8\] _0378_ _0383_ TX.baud_counter\[9\] VGND VGND VPWR VPWR
+ _0384_ sky130_fd_sc_hd__a22o_1
X_1957_ _1656_ VGND VGND VPWR VPWR _0042_ sky130_fd_sc_hd__clkbuf_1
XFILLER_0_7_167 VGND VGND VPWR VPWR sky130_fd_sc_hd__fill_1
X_3627_ clknet_leaf_2_S_AXI_ACLK _0192_ net155 VGND VGND VPWR VPWR RX.rx_shifter\[25\]
+ sky130_fd_sc_hd__dfrtp_1
X_3558_ clknet_leaf_2_S_AXI_ACLK _0123_ VGND VGND VPWR VPWR RX.uart_stp\[18\] sky130_fd_sc_hd__dfxtp_1
X_1888_ RX.uart_cpb\[19\] _1578_ _1601_ _1602_ VGND VGND VPWR VPWR _1603_ sky130_fd_sc_hd__a211o_1
X_2509_ _0352_ _1526_ _0582_ _0350_ VGND VGND VPWR VPWR _0698_ sky130_fd_sc_hd__a22o_1
Xinput107 uart_rx_i VGND VGND VPWR VPWR net107 sky130_fd_sc_hd__clkbuf_4
X_3489_ clknet_leaf_8_S_AXI_ACLK _0054_ VGND VGND VPWR VPWR uart_rdr\[14\] sky130_fd_sc_hd__dfxtp_1
XPHY_113 VGND VGND VPWR VPWR sky130_fd_sc_hd__decap_3
XPHY_102 VGND VGND VPWR VPWR sky130_fd_sc_hd__decap_3
XFILLER_0_34_298 VGND VGND VPWR VPWR sky130_fd_sc_hd__fill_2
XFILLER_0_34_210 VGND VGND VPWR VPWR sky130_fd_sc_hd__fill_2
XFILLER_0_57_335 VGND VGND VPWR VPWR sky130_fd_sc_hd__fill_1
XFILLER_0_57_324 VGND VGND VPWR VPWR sky130_fd_sc_hd__fill_1
XFILLER_0_25_243 VGND VGND VPWR VPWR sky130_fd_sc_hd__fill_1
X_2791_ RX.baud_cnt\[31\] _0451_ VGND VGND VPWR VPWR _0968_ sky130_fd_sc_hd__or2_1
XPHY_4 VGND VGND VPWR VPWR sky130_fd_sc_hd__decap_3
X_1811_ RX.uart_cpb\[4\] VGND VGND VPWR VPWR _1541_ sky130_fd_sc_hd__clkbuf_4
X_2860_ RX.baud_cnt\[12\] VGND VGND VPWR VPWR _1037_ sky130_fd_sc_hd__inv_2
X_1742_ net238 _1483_ VGND VGND VPWR VPWR _1484_ sky130_fd_sc_hd__or2_1
XFILLER_0_0_343 VGND VGND VPWR VPWR sky130_fd_sc_hd__decap_6
XFILLER_0_0_321 VGND VGND VPWR VPWR sky130_fd_sc_hd__decap_8
X_3412_ TX.data_latch_next\[6\] net327 _1440_ VGND VGND VPWR VPWR _1447_ sky130_fd_sc_hd__mux2_1
X_3274_ _1646_ _1154_ _0878_ VGND VGND VPWR VPWR _0233_ sky130_fd_sc_hd__o21a_1
X_3343_ _1369_ _1398_ _1399_ _1368_ TX.baud_counter\[16\] VGND VGND VPWR VPWR _0250_
+ sky130_fd_sc_hd__a32o_1
X_2225_ _0427_ _0431_ _0435_ VGND VGND VPWR VPWR _0436_ sky130_fd_sc_hd__a21o_1
X_2087_ _0312_ VGND VGND VPWR VPWR _0313_ sky130_fd_sc_hd__clkbuf_4
X_2156_ _0361_ _0366_ VGND VGND VPWR VPWR _0367_ sky130_fd_sc_hd__and2_1
XFILLER_0_33_91 VGND VGND VPWR VPWR sky130_fd_sc_hd__decap_3
X_2989_ RX.state\[0\] RX.state\[1\] VGND VGND VPWR VPWR _1163_ sky130_fd_sc_hd__or2_4
X_2010_ _1690_ RX.rx_shifter\[19\] _1672_ uart_rdr\[19\] VGND VGND VPWR VPWR _1693_
+ sky130_fd_sc_hd__a22o_1
XFILLER_0_38_47 VGND VGND VPWR VPWR sky130_fd_sc_hd__fill_2
X_2912_ RX.baud_cnt\[14\] _0845_ _0805_ _0910_ VGND VGND VPWR VPWR _1089_ sky130_fd_sc_hd__a22o_1
X_1725_ net48 net47 net50 net49 VGND VGND VPWR VPWR _1467_ sky130_fd_sc_hd__or4_1
X_2774_ _0921_ _0923_ _0950_ VGND VGND VPWR VPWR _0951_ sky130_fd_sc_hd__and3_1
X_2843_ _0297_ RX.baud_cnt\[1\] RX.baud_cnt\[0\] _0293_ VGND VGND VPWR VPWR _1020_
+ sky130_fd_sc_hd__a22o_1
XTAP_441 VGND VPWR sky130_fd_sc_hd__tapvpwrvgnd_1
XTAP_430 VGND VPWR sky130_fd_sc_hd__tapvpwrvgnd_1
Xhold103 RX.uart_stp\[20\] VGND VGND VPWR VPWR net270 sky130_fd_sc_hd__dlygate4sd3_1
Xhold147 RX.rx_shifter\[1\] VGND VGND VPWR VPWR net314 sky130_fd_sc_hd__dlygate4sd3_1
Xhold158 RX.rx_shifter\[3\] VGND VGND VPWR VPWR net325 sky130_fd_sc_hd__dlygate4sd3_1
Xhold136 TX.data_latch_next\[3\] VGND VGND VPWR VPWR net303 sky130_fd_sc_hd__dlygate4sd3_1
X_3326_ TX.baud_counter\[12\] _1385_ VGND VGND VPWR VPWR _1387_ sky130_fd_sc_hd__or2_1
Xhold114 TX.baud_counter\[11\] VGND VGND VPWR VPWR net281 sky130_fd_sc_hd__dlygate4sd3_1
Xhold125 RX.uart_stp\[4\] VGND VGND VPWR VPWR net292 sky130_fd_sc_hd__dlygate4sd3_1
XTAP_474 VGND VPWR sky130_fd_sc_hd__tapvpwrvgnd_1
XTAP_463 VGND VPWR sky130_fd_sc_hd__tapvpwrvgnd_1
XTAP_452 VGND VPWR sky130_fd_sc_hd__tapvpwrvgnd_1
X_2139_ RX.uart_cpb\[21\] VGND VGND VPWR VPWR _0350_ sky130_fd_sc_hd__inv_2
X_3257_ _1485_ VGND VGND VPWR VPWR _1336_ sky130_fd_sc_hd__clkbuf_4
X_3188_ net87 _1292_ _1294_ _0890_ VGND VGND VPWR VPWR _0200_ sky130_fd_sc_hd__o211a_1
X_2208_ RX.uart_cpb\[19\] VGND VGND VPWR VPWR _0419_ sky130_fd_sc_hd__inv_2
XFILLER_0_28_80 VGND VGND VPWR VPWR sky130_fd_sc_hd__decap_4
Xclkbuf_1_0__f_S_AXI_ACLK clknet_0_S_AXI_ACLK VGND VGND VPWR VPWR clknet_1_0__leaf_S_AXI_ACLK
+ sky130_fd_sc_hd__clkbuf_16
X_2490_ RX.uart_cpb\[15\] _1526_ _0582_ RX.uart_cpb\[16\] VGND VGND VPWR VPWR _0679_
+ sky130_fd_sc_hd__a22o_1
XFILLER_0_4_15 VPWR VGND VPWR VGND sky130_ef_sc_hd__decap_12
X_3111_ RX.bit_idx\[2\] _1242_ VGND VGND VPWR VPWR _1250_ sky130_fd_sc_hd__xor2_1
X_3042_ _0936_ _1198_ RX.baud_cnt\[16\] VGND VGND VPWR VPWR _1201_ sky130_fd_sc_hd__a21o_1
X_2826_ _1000_ _0902_ RX.baud_cnt\[16\] _1002_ VGND VGND VPWR VPWR _1003_ sky130_fd_sc_hd__o22ai_1
X_2688_ net70 TX.tx_enable _0876_ VGND VGND VPWR VPWR _0877_ sky130_fd_sc_hd__mux2_1
X_2757_ _0912_ _0932_ _0933_ VGND VGND VPWR VPWR _0934_ sky130_fd_sc_hd__o21ai_1
XTAP_293 VGND VPWR sky130_fd_sc_hd__tapvpwrvgnd_1
XTAP_282 VGND VPWR sky130_fd_sc_hd__tapvpwrvgnd_1
XTAP_271 VGND VPWR sky130_fd_sc_hd__tapvpwrvgnd_1
X_3309_ _1369_ _1373_ _1374_ _1368_ net305 VGND VGND VPWR VPWR _0241_ sky130_fd_sc_hd__a32o_1
XTAP_260 VGND VPWR sky130_fd_sc_hd__tapvpwrvgnd_1
X_1990_ _1679_ VGND VGND VPWR VPWR _0052_ sky130_fd_sc_hd__clkbuf_1
XFILLER_0_27_124 VGND VGND VPWR VPWR sky130_fd_sc_hd__fill_1
X_3660_ clknet_leaf_2_S_AXI_ACLK _0225_ VGND VGND VPWR VPWR RX.uart_stp\[26\] sky130_fd_sc_hd__dfxtp_1
X_2542_ _0726_ _0727_ _0728_ _0730_ VGND VGND VPWR VPWR _0731_ sky130_fd_sc_hd__a31o_1
X_2611_ _0660_ _0669_ VGND VGND VPWR VPWR _0800_ sky130_fd_sc_hd__nand2_2
X_3591_ clknet_leaf_21_S_AXI_ACLK _0156_ net147 VGND VGND VPWR VPWR RX.baud_cnt\[24\]
+ sky130_fd_sc_hd__dfrtp_4
X_2473_ _0540_ _0541_ _0661_ VGND VGND VPWR VPWR _0662_ sky130_fd_sc_hd__nand3_1
X_3025_ RX.baud_cnt\[10\] _1187_ _1189_ VGND VGND VPWR VPWR _0142_ sky130_fd_sc_hd__o21a_1
XFILLER_0_33_105 VGND VGND VPWR VPWR sky130_fd_sc_hd__fill_2
XFILLER_0_18_157 VGND VGND VPWR VPWR sky130_fd_sc_hd__decap_6
X_2809_ _0449_ RX.baud_cnt\[30\] VGND VGND VPWR VPWR _0986_ sky130_fd_sc_hd__or2_1
XFILLER_0_1_290 VPWR VGND VPWR VGND sky130_ef_sc_hd__decap_12
XFILLER_0_1_49 VGND VGND VPWR VPWR sky130_fd_sc_hd__decap_6
X_1973_ RX.done_reg VGND VGND VPWR VPWR _1667_ sky130_fd_sc_hd__clkbuf_4
X_3712_ clknet_leaf_6_S_AXI_ACLK _0277_ VGND VGND VPWR VPWR RX.uart_stp\[11\] sky130_fd_sc_hd__dfxtp_1
X_3643_ clknet_leaf_0_S_AXI_ACLK _0208_ VGND VGND VPWR VPWR RX.uart_cpb\[17\] sky130_fd_sc_hd__dfxtp_2
X_2525_ _0348_ _0313_ _0604_ _0428_ _0713_ VGND VGND VPWR VPWR _0714_ sky130_fd_sc_hd__o221a_1
X_3574_ clknet_leaf_18_S_AXI_ACLK _0139_ net151 VGND VGND VPWR VPWR RX.baud_cnt\[7\]
+ sky130_fd_sc_hd__dfrtp_4
Xhold29 net132 VGND VGND VPWR VPWR net196 sky130_fd_sc_hd__dlygate4sd3_1
X_2387_ _0575_ VGND VGND VPWR VPWR _0576_ sky130_fd_sc_hd__clkbuf_4
Xhold18 net139 VGND VGND VPWR VPWR net185 sky130_fd_sc_hd__dlygate4sd3_1
X_2456_ _0530_ _0533_ VGND VGND VPWR VPWR _0645_ sky130_fd_sc_hd__nand2_1
X_3008_ _1014_ _1173_ VGND VGND VPWR VPWR _1177_ sky130_fd_sc_hd__nor2_1
XFILLER_0_46_230 VGND VGND VPWR VPWR sky130_fd_sc_hd__fill_1
XFILLER_0_52_233 VGND VGND VPWR VPWR sky130_fd_sc_hd__fill_1
XFILLER_0_57_79 VGND VGND VPWR VPWR sky130_fd_sc_hd__fill_2
X_2310_ net266 _0497_ VGND VGND VPWR VPWR _0503_ sky130_fd_sc_hd__or2_1
X_3290_ TX.baud_counter\[0\] TX.baud_counter\[1\] TX.baud_counter\[3\] TX.baud_counter\[2\]
+ VGND VGND VPWR VPWR _1360_ sky130_fd_sc_hd__and4_2
X_2172_ _0381_ _0382_ VGND VGND VPWR VPWR _0383_ sky130_fd_sc_hd__and2_1
XFILLER_0_20_163 VGND VGND VPWR VPWR sky130_fd_sc_hd__fill_1
X_2241_ _1639_ _0447_ VGND VGND VPWR VPWR _0452_ sky130_fd_sc_hd__and2_1
XFILLER_0_25_9 VGND VGND VPWR VPWR sky130_fd_sc_hd__fill_2
X_1887_ uart_rdr\[19\] _1580_ _1590_ VGND VGND VPWR VPWR _1602_ sky130_fd_sc_hd__a21bo_1
X_1956_ _1654_ _1655_ VGND VGND VPWR VPWR _1656_ sky130_fd_sc_hd__and2_1
X_3626_ clknet_leaf_2_S_AXI_ACLK _0191_ net155 VGND VGND VPWR VPWR RX.rx_shifter\[24\]
+ sky130_fd_sc_hd__dfrtp_1
X_3488_ clknet_leaf_8_S_AXI_ACLK _0053_ VGND VGND VPWR VPWR uart_rdr\[13\] sky130_fd_sc_hd__dfxtp_1
X_3557_ clknet_leaf_2_S_AXI_ACLK _0122_ VGND VGND VPWR VPWR RX.uart_stp\[17\] sky130_fd_sc_hd__dfxtp_1
X_2508_ _0563_ _0695_ _0565_ VGND VGND VPWR VPWR _0697_ sky130_fd_sc_hd__o21bai_1
X_2439_ _0625_ _0576_ _0626_ _0627_ VGND VGND VPWR VPWR _0628_ sky130_fd_sc_hd__a31o_1
XPHY_114 VGND VGND VPWR VPWR sky130_fd_sc_hd__decap_3
XPHY_103 VGND VGND VPWR VPWR sky130_fd_sc_hd__decap_3
XFILLER_0_34_244 VGND VGND VPWR VPWR sky130_fd_sc_hd__fill_1
XPHY_5 VGND VGND VPWR VPWR sky130_fd_sc_hd__decap_3
X_1810_ _1534_ net186 _1524_ _1540_ VGND VGND VPWR VPWR _0011_ sky130_fd_sc_hd__o211a_1
X_1741_ _1479_ _1480_ VGND VGND VPWR VPWR _1483_ sky130_fd_sc_hd__nor2_2
X_2790_ RX.baud_cnt\[31\] _0451_ VGND VGND VPWR VPWR _0967_ sky130_fd_sc_hd__and2_1
XFILLER_0_4_116 VGND VGND VPWR VPWR sky130_fd_sc_hd__fill_1
X_3342_ TX.baud_counter\[16\] _1396_ _1353_ VGND VGND VPWR VPWR _1399_ sky130_fd_sc_hd__a21oi_1
X_3411_ _1446_ VGND VGND VPWR VPWR _0271_ sky130_fd_sc_hd__clkbuf_1
X_3273_ _0472_ _1340_ _1346_ TX.state\[1\] VGND VGND VPWR VPWR _0232_ sky130_fd_sc_hd__a22o_1
X_2155_ RX.uart_cpb\[1\] _1522_ _1532_ VGND VGND VPWR VPWR _0366_ sky130_fd_sc_hd__o21ai_1
X_2224_ TX.baud_counter\[24\] _0430_ _0434_ TX.baud_counter\[25\] VGND VGND VPWR VPWR
+ _0435_ sky130_fd_sc_hd__a22o_1
X_2086_ RX.uart_stp\[1\] VGND VGND VPWR VPWR _0312_ sky130_fd_sc_hd__inv_2
X_1939_ _1609_ net178 _1635_ _1642_ VGND VGND VPWR VPWR _0038_ sky130_fd_sc_hd__o211a_1
X_3609_ clknet_leaf_11_S_AXI_ACLK _0174_ net160 VGND VGND VPWR VPWR RX.rx_shifter\[7\]
+ sky130_fd_sc_hd__dfrtp_1
XFILLER_0_31_225 VGND VGND VPWR VPWR sky130_fd_sc_hd__fill_2
X_2988_ RX.baud_cnt\[1\] RX.baud_cnt\[0\] VGND VGND VPWR VPWR _1162_ sky130_fd_sc_hd__nand2_1
Xinput90 S_AXI_WDATA[28] VGND VGND VPWR VPWR net90 sky130_fd_sc_hd__clkbuf_2
XFILLER_0_13_29 VGND VGND VPWR VPWR sky130_fd_sc_hd__fill_1
XFILLER_0_57_177 VGND VGND VPWR VPWR sky130_fd_sc_hd__fill_2
XFILLER_0_54_58 VGND VGND VPWR VPWR sky130_fd_sc_hd__decap_8
XFILLER_0_9_219 VGND VGND VPWR VPWR sky130_fd_sc_hd__fill_1
X_2911_ _0936_ _0850_ VGND VGND VPWR VPWR _1088_ sky130_fd_sc_hd__and2_1
Xhold115 RX.uart_stp\[27\] VGND VGND VPWR VPWR net282 sky130_fd_sc_hd__dlygate4sd3_1
Xhold126 net121 VGND VGND VPWR VPWR net293 sky130_fd_sc_hd__dlygate4sd3_1
X_1724_ net60 VGND VGND VPWR VPWR _1466_ sky130_fd_sc_hd__inv_2
X_2773_ _0927_ _0925_ _0949_ _0924_ VGND VGND VPWR VPWR _0950_ sky130_fd_sc_hd__and4bb_1
X_2842_ _1535_ _1018_ VGND VGND VPWR VPWR _1019_ sky130_fd_sc_hd__or2_1
Xhold104 net137 VGND VGND VPWR VPWR net271 sky130_fd_sc_hd__dlygate4sd3_1
XTAP_475 VGND VPWR sky130_fd_sc_hd__tapvpwrvgnd_1
XTAP_464 VGND VPWR sky130_fd_sc_hd__tapvpwrvgnd_1
XTAP_453 VGND VPWR sky130_fd_sc_hd__tapvpwrvgnd_1
XTAP_442 VGND VPWR sky130_fd_sc_hd__tapvpwrvgnd_1
XTAP_431 VGND VPWR sky130_fd_sc_hd__tapvpwrvgnd_1
X_3256_ net229 _1329_ VGND VGND VPWR VPWR _1335_ sky130_fd_sc_hd__or2_1
XTAP_420 VGND VPWR sky130_fd_sc_hd__tapvpwrvgnd_1
Xhold148 RX.rx_shifter\[2\] VGND VGND VPWR VPWR net315 sky130_fd_sc_hd__dlygate4sd3_1
Xhold159 RX.rx_shifter\[0\] VGND VGND VPWR VPWR net326 sky130_fd_sc_hd__dlygate4sd3_1
Xhold137 _1444_ VGND VGND VPWR VPWR net304 sky130_fd_sc_hd__dlygate4sd3_1
X_3325_ _1369_ _1384_ _1386_ _1368_ net281 VGND VGND VPWR VPWR _0245_ sky130_fd_sc_hd__a32o_1
X_3187_ _0723_ _1292_ VGND VGND VPWR VPWR _1294_ sky130_fd_sc_hd__nand2_1
X_2138_ _0348_ _0345_ VGND VGND VPWR VPWR _0349_ sky130_fd_sc_hd__xnor2_2
X_2069_ _1541_ VGND VGND VPWR VPWR _0300_ sky130_fd_sc_hd__inv_2
X_2207_ _0411_ _0415_ _0416_ TX.baud_counter\[18\] _0417_ VGND VGND VPWR VPWR _0418_
+ sky130_fd_sc_hd__o221a_1
XFILLER_0_39_111 VGND VGND VPWR VPWR sky130_fd_sc_hd__fill_1
XFILLER_0_27_317 VGND VGND VPWR VPWR sky130_fd_sc_hd__fill_1
XFILLER_0_42_309 VGND VGND VPWR VPWR sky130_fd_sc_hd__fill_1
XFILLER_0_40_27 VGND VGND VPWR VPWR sky130_fd_sc_hd__fill_1
X_3110_ _1150_ _1155_ VGND VGND VPWR VPWR _1249_ sky130_fd_sc_hd__nor2_1
XFILLER_0_4_27 VGND VGND VPWR VPWR sky130_fd_sc_hd__fill_1
XFILLER_0_10_217 VGND VGND VPWR VPWR sky130_fd_sc_hd__decap_8
X_3041_ _1194_ _1198_ _1200_ _1199_ _0936_ VGND VGND VPWR VPWR _0147_ sky130_fd_sc_hd__a32o_1
XFILLER_0_45_169 VGND VGND VPWR VPWR sky130_fd_sc_hd__fill_1
XFILLER_0_45_158 VGND VGND VPWR VPWR sky130_fd_sc_hd__fill_2
X_2825_ RX.uart_cpb\[17\] VGND VGND VPWR VPWR _1002_ sky130_fd_sc_hd__inv_2
XFILLER_0_33_309 VGND VGND VPWR VPWR sky130_fd_sc_hd__fill_1
XFILLER_0_5_222 VGND VGND VPWR VPWR sky130_fd_sc_hd__fill_2
XFILLER_0_5_211 VGND VGND VPWR VPWR sky130_fd_sc_hd__fill_2
XFILLER_0_30_82 VGND VGND VPWR VPWR sky130_fd_sc_hd__fill_2
X_2687_ net57 _0286_ _0875_ VGND VGND VPWR VPWR _0876_ sky130_fd_sc_hd__or3_1
X_2756_ RX.baud_cnt\[12\] _0393_ _0398_ RX.baud_cnt\[13\] VGND VGND VPWR VPWR _0933_
+ sky130_fd_sc_hd__o22a_1
X_3239_ _0403_ _1315_ VGND VGND VPWR VPWR _1325_ sky130_fd_sc_hd__nand2_1
XTAP_294 VGND VPWR sky130_fd_sc_hd__tapvpwrvgnd_1
XTAP_283 VGND VPWR sky130_fd_sc_hd__tapvpwrvgnd_1
XTAP_272 VGND VPWR sky130_fd_sc_hd__tapvpwrvgnd_1
X_3308_ TX.baud_counter\[7\] _1371_ _1353_ VGND VGND VPWR VPWR _1374_ sky130_fd_sc_hd__a21oi_1
XTAP_250 VGND VPWR sky130_fd_sc_hd__tapvpwrvgnd_1
XTAP_261 VGND VPWR sky130_fd_sc_hd__tapvpwrvgnd_1
XFILLER_0_36_114 VGND VGND VPWR VPWR sky130_fd_sc_hd__fill_2
XFILLER_0_10_19 VGND VGND VPWR VPWR sky130_fd_sc_hd__fill_1
XFILLER_0_51_15 VGND VGND VPWR VPWR sky130_fd_sc_hd__decap_6
X_2541_ _0577_ _0729_ VGND VGND VPWR VPWR _0730_ sky130_fd_sc_hd__nand2_1
X_2472_ _0534_ _0537_ _0542_ VGND VGND VPWR VPWR _0661_ sky130_fd_sc_hd__a21o_1
X_3590_ clknet_leaf_21_S_AXI_ACLK _0155_ net147 VGND VGND VPWR VPWR RX.baud_cnt\[23\]
+ sky130_fd_sc_hd__dfrtp_1
X_2610_ TX.baud_counter\[18\] _0796_ _0798_ TX.baud_counter\[17\] VGND VGND VPWR VPWR
+ _0799_ sky130_fd_sc_hd__o22a_1
X_3024_ _1176_ _1188_ _1152_ VGND VGND VPWR VPWR _1189_ sky130_fd_sc_hd__o21bai_1
X_2808_ _0749_ RX.baud_cnt\[28\] _0977_ _0978_ _0984_ VGND VGND VPWR VPWR _0985_ sky130_fd_sc_hd__o221a_1
XFILLER_0_41_161 VGND VGND VPWR VPWR sky130_fd_sc_hd__fill_2
X_2739_ RX.baud_cnt\[8\] _0378_ _0383_ RX.baud_cnt\[9\] VGND VGND VPWR VPWR _0916_
+ sky130_fd_sc_hd__o22a_1
XFILLER_0_5_81 VGND VGND VPWR VPWR sky130_fd_sc_hd__fill_2
Xclkbuf_leaf_19_S_AXI_ACLK clknet_1_0__leaf_S_AXI_ACLK VGND VGND VPWR VPWR clknet_leaf_19_S_AXI_ACLK
+ sky130_fd_sc_hd__clkbuf_16
XFILLER_0_32_150 VGND VGND VPWR VPWR sky130_fd_sc_hd__decap_3
X_3711_ clknet_leaf_8_S_AXI_ACLK _0276_ VGND VGND VPWR VPWR RX.uart_stp\[10\] sky130_fd_sc_hd__dfxtp_1
X_3642_ clknet_leaf_0_S_AXI_ACLK _0207_ VGND VGND VPWR VPWR RX.uart_cpb\[16\] sky130_fd_sc_hd__dfxtp_4
X_1972_ _1666_ VGND VGND VPWR VPWR _0047_ sky130_fd_sc_hd__clkbuf_1
X_2524_ _0707_ _0709_ _0710_ _0712_ VGND VGND VPWR VPWR _0713_ sky130_fd_sc_hd__a31o_1
X_3573_ clknet_leaf_18_S_AXI_ACLK _0138_ net151 VGND VGND VPWR VPWR RX.baud_cnt\[6\]
+ sky130_fd_sc_hd__dfrtp_2
X_2455_ _0641_ _0642_ _0643_ VGND VGND VPWR VPWR _0644_ sky130_fd_sc_hd__o21ai_2
Xhold19 net136 VGND VGND VPWR VPWR net186 sky130_fd_sc_hd__dlygate4sd3_1
X_2386_ RX.uart_stp\[1\] RX.uart_stp\[0\] VGND VGND VPWR VPWR _0575_ sky130_fd_sc_hd__and2b_1
XFILLER_0_38_209 VGND VGND VPWR VPWR sky130_fd_sc_hd__fill_2
X_3007_ _1157_ VGND VGND VPWR VPWR _1176_ sky130_fd_sc_hd__clkbuf_4
XFILLER_0_6_350 VGND VGND VPWR VPWR sky130_fd_sc_hd__fill_1
XFILLER_0_14_161 VGND VGND VPWR VPWR sky130_fd_sc_hd__decap_3
XFILLER_0_29_209 VGND VGND VPWR VPWR sky130_fd_sc_hd__fill_1
XFILLER_0_16_29 VGND VGND VPWR VPWR sky130_fd_sc_hd__decap_4
X_2240_ RX.uart_cpb\[31\] _0448_ _0450_ VGND VGND VPWR VPWR _0451_ sky130_fd_sc_hd__o21ai_2
X_2171_ _1557_ _0336_ _1562_ VGND VGND VPWR VPWR _0382_ sky130_fd_sc_hd__o21ai_1
X_3625_ clknet_leaf_2_S_AXI_ACLK _0190_ net155 VGND VGND VPWR VPWR RX.rx_shifter\[23\]
+ sky130_fd_sc_hd__dfrtp_1
XFILLER_0_43_223 VGND VGND VPWR VPWR sky130_fd_sc_hd__fill_1
X_1955_ _1646_ RX.rx_shifter\[2\] _1649_ uart_rdr\[2\] VGND VGND VPWR VPWR _1655_
+ sky130_fd_sc_hd__a22o_1
X_1886_ TX.uart_tdr\[19\] _1566_ _1567_ RX.uart_stp\[19\] VGND VGND VPWR VPWR _1601_
+ sky130_fd_sc_hd__a22o_1
XFILLER_0_3_320 VPWR VGND VPWR VGND sky130_ef_sc_hd__decap_12
XFILLER_0_7_169 VGND VGND VPWR VPWR sky130_fd_sc_hd__fill_2
XFILLER_0_22_83 VGND VGND VPWR VPWR sky130_fd_sc_hd__fill_1
XFILLER_0_51_3 VPWR VGND VPWR VGND sky130_ef_sc_hd__decap_12
X_3487_ clknet_leaf_8_S_AXI_ACLK _0052_ VGND VGND VPWR VPWR uart_rdr\[12\] sky130_fd_sc_hd__dfxtp_1
X_3556_ clknet_leaf_0_S_AXI_ACLK _0121_ VGND VGND VPWR VPWR RX.uart_stp\[16\] sky130_fd_sc_hd__dfxtp_1
X_2507_ _0563_ _0695_ _0565_ VGND VGND VPWR VPWR _0696_ sky130_fd_sc_hd__or3b_1
X_2438_ _1525_ RX.uart_cpb\[1\] _0581_ _1532_ VGND VGND VPWR VPWR _0627_ sky130_fd_sc_hd__a22o_1
X_2369_ _0556_ _0557_ VGND VGND VPWR VPWR _0558_ sky130_fd_sc_hd__nor2_1
XPHY_115 VGND VGND VPWR VPWR sky130_fd_sc_hd__decap_3
XPHY_104 VGND VGND VPWR VPWR sky130_fd_sc_hd__decap_3
XFILLER_0_34_234 VGND VGND VPWR VPWR sky130_fd_sc_hd__fill_2
Xclkbuf_leaf_9_S_AXI_ACLK clknet_1_1__leaf_S_AXI_ACLK VGND VGND VPWR VPWR clknet_leaf_9_S_AXI_ACLK
+ sky130_fd_sc_hd__clkbuf_16
XFILLER_0_27_28 VGND VGND VPWR VPWR sky130_fd_sc_hd__fill_2
XFILLER_0_57_337 VGND VGND VPWR VPWR sky130_fd_sc_hd__fill_2
XPHY_6 VGND VGND VPWR VPWR sky130_fd_sc_hd__decap_3
X_1740_ _1481_ VGND VGND VPWR VPWR _1482_ sky130_fd_sc_hd__buf_2
XFILLER_0_25_223 VGND VGND VPWR VPWR sky130_fd_sc_hd__fill_1
XFILLER_0_0_356 VGND VGND VPWR VPWR sky130_fd_sc_hd__fill_2
X_3341_ TX.baud_counter\[16\] _1396_ VGND VGND VPWR VPWR _1398_ sky130_fd_sc_hd__or2_1
X_3410_ TX.data_latch_next\[5\] net319 _1440_ VGND VGND VPWR VPWR _1446_ sky130_fd_sc_hd__mux2_1
X_3272_ _1347_ VGND VGND VPWR VPWR _0231_ sky130_fd_sc_hd__clkbuf_1
X_2085_ net70 _0309_ _0311_ _0296_ VGND VGND VPWR VPWR _0080_ sky130_fd_sc_hd__o211a_1
X_2223_ _0432_ _0433_ VGND VGND VPWR VPWR _0434_ sky130_fd_sc_hd__and2_1
X_2154_ _1522_ TX.baud_counter\[0\] TX.baud_counter\[1\] _0363_ VGND VGND VPWR VPWR
+ _0365_ sky130_fd_sc_hd__o22a_1
XFILLER_0_17_83 VGND VGND VPWR VPWR sky130_fd_sc_hd__decap_6
XFILLER_0_23_7 VGND VGND VPWR VPWR sky130_fd_sc_hd__fill_1
X_2987_ RX.baud_cnt\[0\] _1159_ _1161_ _1154_ VGND VGND VPWR VPWR _0132_ sky130_fd_sc_hd__o22a_1
Xinput91 S_AXI_WDATA[29] VGND VGND VPWR VPWR net91 sky130_fd_sc_hd__buf_1
Xinput80 S_AXI_WDATA[19] VGND VGND VPWR VPWR net80 sky130_fd_sc_hd__buf_1
X_1869_ RX.uart_cpb\[15\] _1578_ _1586_ _1587_ VGND VGND VPWR VPWR _1588_ sky130_fd_sc_hd__a211o_1
X_1938_ _1639_ _1521_ _1640_ _1641_ VGND VGND VPWR VPWR _1642_ sky130_fd_sc_hd__a211o_1
X_3608_ clknet_leaf_10_S_AXI_ACLK _0173_ net160 VGND VGND VPWR VPWR RX.rx_shifter\[6\]
+ sky130_fd_sc_hd__dfrtp_1
X_3539_ clknet_leaf_1_S_AXI_ACLK _0104_ VGND VGND VPWR VPWR TX.uart_tdr\[18\] sky130_fd_sc_hd__dfxtp_1
X_2910_ _0936_ _0850_ VGND VGND VPWR VPWR _1087_ sky130_fd_sc_hd__nor2_1
X_2841_ RX.baud_cnt\[2\] VGND VGND VPWR VPWR _1018_ sky130_fd_sc_hd__inv_2
Xhold127 RX.uart_stp\[18\] VGND VGND VPWR VPWR net294 sky130_fd_sc_hd__dlygate4sd3_1
Xhold149 RX.rx_shifter\[5\] VGND VGND VPWR VPWR net316 sky130_fd_sc_hd__dlygate4sd3_1
X_2772_ RX.baud_cnt\[2\] _0367_ RX.baud_cnt\[0\] _1522_ VGND VGND VPWR VPWR _0949_
+ sky130_fd_sc_hd__o2bb2a_1
Xhold138 TX.baud_counter\[7\] VGND VGND VPWR VPWR net305 sky130_fd_sc_hd__dlygate4sd3_1
Xhold116 TX.baud_counter\[26\] VGND VGND VPWR VPWR net283 sky130_fd_sc_hd__dlygate4sd3_1
X_1723_ _1461_ _1464_ _1465_ VGND VGND VPWR VPWR net145 sky130_fd_sc_hd__o21a_1
Xhold105 RX.uart_stp\[2\] VGND VGND VPWR VPWR net272 sky130_fd_sc_hd__dlygate4sd3_1
XTAP_465 VGND VPWR sky130_fd_sc_hd__tapvpwrvgnd_1
XTAP_454 VGND VPWR sky130_fd_sc_hd__tapvpwrvgnd_1
XTAP_443 VGND VPWR sky130_fd_sc_hd__tapvpwrvgnd_1
XTAP_432 VGND VPWR sky130_fd_sc_hd__tapvpwrvgnd_1
XTAP_421 VGND VPWR sky130_fd_sc_hd__tapvpwrvgnd_1
XTAP_410 VGND VPWR sky130_fd_sc_hd__tapvpwrvgnd_1
X_3255_ net90 _1328_ _1334_ _1322_ VGND VGND VPWR VPWR _0227_ sky130_fd_sc_hd__o211a_1
X_3324_ _1353_ _1385_ VGND VGND VPWR VPWR _1386_ sky130_fd_sc_hd__nor2_1
X_2206_ TX.baud_counter\[17\] _0414_ VGND VGND VPWR VPWR _0417_ sky130_fd_sc_hd__or2_1
X_3186_ net86 _1292_ _1293_ _0890_ VGND VGND VPWR VPWR _0199_ sky130_fd_sc_hd__o211a_1
X_2137_ RX.uart_cpb\[23\] VGND VGND VPWR VPWR _0348_ sky130_fd_sc_hd__inv_2
X_2068_ net95 _0291_ _0299_ VGND VGND VPWR VPWR _0075_ sky130_fd_sc_hd__a21o_1
XFILLER_0_8_275 VGND VGND VPWR VPWR sky130_fd_sc_hd__fill_2
XFILLER_0_24_29 VGND VGND VPWR VPWR sky130_fd_sc_hd__decap_4
XFILLER_0_35_362 VGND VGND VPWR VPWR sky130_fd_sc_hd__fill_2
X_3040_ _0936_ _1160_ VGND VGND VPWR VPWR _1200_ sky130_fd_sc_hd__nor2_1
X_2824_ _0419_ RX.baud_cnt\[18\] _0902_ _1000_ VGND VGND VPWR VPWR _1001_ sky130_fd_sc_hd__a22o_1
X_2686_ _0874_ _1471_ _1472_ _0288_ VGND VGND VPWR VPWR _0875_ sky130_fd_sc_hd__or4_1
X_2755_ _0914_ _0916_ _0913_ VGND VGND VPWR VPWR _0932_ sky130_fd_sc_hd__o21a_1
X_3169_ _1283_ VGND VGND VPWR VPWR _0192_ sky130_fd_sc_hd__clkbuf_1
X_3238_ net74 _1318_ _1324_ _1322_ VGND VGND VPWR VPWR _0220_ sky130_fd_sc_hd__o211a_1
XTAP_295 VGND VPWR sky130_fd_sc_hd__tapvpwrvgnd_1
XTAP_284 VGND VPWR sky130_fd_sc_hd__tapvpwrvgnd_1
XTAP_273 VGND VPWR sky130_fd_sc_hd__tapvpwrvgnd_1
X_3307_ TX.baud_counter\[7\] _1371_ VGND VGND VPWR VPWR _1373_ sky130_fd_sc_hd__or2_1
XTAP_240 VGND VPWR sky130_fd_sc_hd__tapvpwrvgnd_1
XTAP_251 VGND VPWR sky130_fd_sc_hd__tapvpwrvgnd_1
XTAP_262 VGND VPWR sky130_fd_sc_hd__tapvpwrvgnd_1
XFILLER_0_32_321 VGND VGND VPWR VPWR sky130_fd_sc_hd__fill_1
XFILLER_0_3_3 VPWR VGND VPWR VGND sky130_ef_sc_hd__decap_12
X_2540_ _0727_ _0728_ _0726_ VGND VGND VPWR VPWR _0729_ sky130_fd_sc_hd__a21o_1
X_2471_ _0648_ _0654_ _0659_ VGND VGND VPWR VPWR _0660_ sky130_fd_sc_hd__and3_2
X_3023_ RX.baud_cnt\[10\] RX.baud_cnt\[9\] _1181_ VGND VGND VPWR VPWR _1188_ sky130_fd_sc_hd__and3_1
X_2807_ _0980_ _0982_ _0983_ VGND VGND VPWR VPWR _0984_ sky130_fd_sc_hd__or3b_1
X_2738_ RX.baud_cnt\[8\] _0378_ VGND VGND VPWR VPWR _0915_ sky130_fd_sc_hd__nand2_1
X_2669_ _0799_ _0851_ _0855_ _0857_ VGND VGND VPWR VPWR _0858_ sky130_fd_sc_hd__a31o_1
XFILLER_0_24_129 VGND VGND VPWR VPWR sky130_fd_sc_hd__fill_2
XFILLER_0_55_298 VPWR VGND VPWR VGND sky130_ef_sc_hd__decap_12
X_3710_ clknet_leaf_6_S_AXI_ACLK _0275_ VGND VGND VPWR VPWR RX.uart_stp\[9\] sky130_fd_sc_hd__dfxtp_1
X_3641_ clknet_leaf_4_S_AXI_ACLK _0206_ VGND VGND VPWR VPWR RX.uart_cpb\[31\] sky130_fd_sc_hd__dfxtp_2
X_1971_ _1654_ _1665_ VGND VGND VPWR VPWR _1666_ sky130_fd_sc_hd__and2_1
X_3572_ clknet_leaf_19_S_AXI_ACLK _0137_ net158 VGND VGND VPWR VPWR RX.baud_cnt\[5\]
+ sky130_fd_sc_hd__dfrtp_4
X_2523_ _0577_ _0711_ VGND VGND VPWR VPWR _0712_ sky130_fd_sc_hd__nand2_1
X_2385_ _0508_ _0570_ _0573_ VGND VGND VPWR VPWR _0574_ sky130_fd_sc_hd__o21ai_1
X_2454_ _0312_ RX.uart_cpb\[6\] _0604_ _1553_ VGND VGND VPWR VPWR _0643_ sky130_fd_sc_hd__o22a_1
X_3006_ _1153_ _1173_ VGND VGND VPWR VPWR _1175_ sky130_fd_sc_hd__nor2_1
Xinput1 S_AXI_ARADDR[0] VGND VGND VPWR VPWR net1 sky130_fd_sc_hd__clkbuf_2
XFILLER_0_57_26 VGND VGND VPWR VPWR sky130_fd_sc_hd__fill_2
X_2170_ _1562_ _1557_ _0336_ VGND VGND VPWR VPWR _0381_ sky130_fd_sc_hd__or3_1
X_1954_ net161 VGND VGND VPWR VPWR _1654_ sky130_fd_sc_hd__buf_2
X_3624_ clknet_leaf_3_S_AXI_ACLK _0189_ net155 VGND VGND VPWR VPWR RX.rx_shifter\[22\]
+ sky130_fd_sc_hd__dfrtp_1
X_1885_ _1485_ VGND VGND VPWR VPWR _1600_ sky130_fd_sc_hd__clkbuf_4
X_3555_ clknet_leaf_12_S_AXI_ACLK _0120_ VGND VGND VPWR VPWR uart_cfg\[2\] sky130_fd_sc_hd__dfxtp_1
XFILLER_0_3_332 VGND VGND VPWR VPWR sky130_fd_sc_hd__decap_4
X_3486_ clknet_leaf_9_S_AXI_ACLK _0051_ VGND VGND VPWR VPWR uart_rdr\[11\] sky130_fd_sc_hd__dfxtp_1
X_2368_ RX.uart_cpb\[20\] RX.uart_cpb\[19\] VGND VGND VPWR VPWR _0557_ sky130_fd_sc_hd__xnor2_1
X_2506_ _0560_ _0562_ _0694_ VGND VGND VPWR VPWR _0695_ sky130_fd_sc_hd__a21oi_1
X_2437_ _0520_ _0521_ VGND VGND VPWR VPWR _0626_ sky130_fd_sc_hd__nand2_1
XPHY_105 VGND VGND VPWR VPWR sky130_fd_sc_hd__decap_3
X_2299_ _0495_ VGND VGND VPWR VPWR _0496_ sky130_fd_sc_hd__buf_2
XFILLER_0_19_232 VGND VGND VPWR VPWR sky130_fd_sc_hd__decap_6
XFILLER_0_42_290 VGND VGND VPWR VPWR sky130_fd_sc_hd__fill_2
XPHY_7 VGND VGND VPWR VPWR sky130_fd_sc_hd__decap_3
X_2222_ RX.uart_cpb\[24\] _0429_ RX.uart_cpb\[25\] VGND VGND VPWR VPWR _0433_ sky130_fd_sc_hd__o21ai_1
X_3271_ _1344_ _1346_ TX.state\[0\] VGND VGND VPWR VPWR _1347_ sky130_fd_sc_hd__mux2_1
XFILLER_0_0_335 VGND VGND VPWR VPWR sky130_fd_sc_hd__fill_1
X_3340_ _1369_ _1395_ _1397_ _1368_ net310 VGND VGND VPWR VPWR _0249_ sky130_fd_sc_hd__a32o_1
X_2084_ RX.uart_stp\[0\] _0310_ VGND VGND VPWR VPWR _0311_ sky130_fd_sc_hd__or2_1
X_2153_ TX.baud_counter\[1\] _0363_ VGND VGND VPWR VPWR _0364_ sky130_fd_sc_hd__and2_1
X_1937_ uart_rdr\[30\] _1513_ _1494_ VGND VGND VPWR VPWR _1641_ sky130_fd_sc_hd__a21bo_1
X_2986_ RX.baud_cnt\[0\] _1160_ VGND VGND VPWR VPWR _1161_ sky130_fd_sc_hd__nor2_1
XFILLER_0_16_213 VPWR VGND VPWR VGND sky130_ef_sc_hd__decap_12
X_1868_ uart_rdr\[15\] _1580_ _1550_ VGND VGND VPWR VPWR _1587_ sky130_fd_sc_hd__a21bo_1
X_3538_ clknet_leaf_2_S_AXI_ACLK _0103_ VGND VGND VPWR VPWR TX.uart_tdr\[17\] sky130_fd_sc_hd__dfxtp_1
X_3607_ clknet_leaf_10_S_AXI_ACLK _0172_ net160 VGND VGND VPWR VPWR RX.rx_shifter\[5\]
+ sky130_fd_sc_hd__dfrtp_1
Xinput70 S_AXI_WDATA[0] VGND VGND VPWR VPWR net70 sky130_fd_sc_hd__clkbuf_2
X_1799_ TX.data_latch_next\[2\] _1507_ _1509_ RX.uart_stp\[2\] _1530_ VGND VGND VPWR
+ VPWR _1531_ sky130_fd_sc_hd__a221o_1
Xinput92 S_AXI_WDATA[2] VGND VGND VPWR VPWR net92 sky130_fd_sc_hd__clkbuf_2
Xinput81 S_AXI_WDATA[1] VGND VGND VPWR VPWR net81 sky130_fd_sc_hd__clkbuf_2
X_3469_ clknet_leaf_1_S_AXI_ACLK _0034_ VGND VGND VPWR VPWR net129 sky130_fd_sc_hd__dfxtp_1
XFILLER_0_54_27 VGND VGND VPWR VPWR sky130_fd_sc_hd__fill_1
XFILLER_0_57_113 VGND VGND VPWR VPWR sky130_fd_sc_hd__fill_1
X_2840_ _1545_ _1016_ _0922_ _0300_ VGND VGND VPWR VPWR _1017_ sky130_fd_sc_hd__a2bb2o_1
X_2771_ _0896_ _0909_ _0947_ VGND VGND VPWR VPWR _0948_ sky130_fd_sc_hd__a21oi_1
Xhold128 RX.rx_shifter\[11\] VGND VGND VPWR VPWR net295 sky130_fd_sc_hd__dlygate4sd3_1
XTAP_400 VGND VPWR sky130_fd_sc_hd__tapvpwrvgnd_1
Xhold117 net123 VGND VGND VPWR VPWR net284 sky130_fd_sc_hd__dlygate4sd3_1
Xhold139 TX.baud_counter\[20\] VGND VGND VPWR VPWR net306 sky130_fd_sc_hd__dlygate4sd3_1
Xhold106 RX.uart_stp\[7\] VGND VGND VPWR VPWR net273 sky130_fd_sc_hd__dlygate4sd3_1
X_1722_ TX.state\[1\] TX.state\[0\] VGND VGND VPWR VPWR _1465_ sky130_fd_sc_hd__or2b_1
XTAP_466 VGND VPWR sky130_fd_sc_hd__tapvpwrvgnd_1
XTAP_455 VGND VPWR sky130_fd_sc_hd__tapvpwrvgnd_1
XTAP_444 VGND VPWR sky130_fd_sc_hd__tapvpwrvgnd_1
XTAP_433 VGND VPWR sky130_fd_sc_hd__tapvpwrvgnd_1
XTAP_422 VGND VPWR sky130_fd_sc_hd__tapvpwrvgnd_1
XTAP_411 VGND VPWR sky130_fd_sc_hd__tapvpwrvgnd_1
X_3254_ net268 _1329_ VGND VGND VPWR VPWR _1334_ sky130_fd_sc_hd__or2_1
X_3185_ _0428_ _1292_ VGND VGND VPWR VPWR _1293_ sky130_fd_sc_hd__nand2_1
X_2205_ _1596_ _0412_ VGND VGND VPWR VPWR _0416_ sky130_fd_sc_hd__xnor2_2
X_3323_ TX.baud_counter\[11\] TX.baud_counter\[10\] _1379_ VGND VGND VPWR VPWR _1385_
+ sky130_fd_sc_hd__and3_1
X_2067_ _1535_ _0290_ _1485_ VGND VGND VPWR VPWR _0299_ sky130_fd_sc_hd__a21bo_1
X_2136_ _0345_ _0346_ VGND VGND VPWR VPWR _0347_ sky130_fd_sc_hd__and2_1
X_2969_ RX.baud_cnt\[31\] _0766_ VGND VGND VPWR VPWR _1146_ sky130_fd_sc_hd__nand2_1
XFILLER_0_40_29 VGND VGND VPWR VPWR sky130_fd_sc_hd__fill_2
XFILLER_0_4_29 VPWR VGND VPWR VGND sky130_ef_sc_hd__decap_12
X_2823_ _1596_ VGND VGND VPWR VPWR _1000_ sky130_fd_sc_hd__inv_2
XFILLER_0_5_279 VGND VGND VPWR VPWR sky130_fd_sc_hd__fill_1
X_2754_ _0920_ _0930_ VGND VGND VPWR VPWR _0931_ sky130_fd_sc_hd__nand2_1
XFILLER_0_14_85 VGND VGND VPWR VPWR sky130_fd_sc_hd__fill_2
X_2685_ net61 VGND VGND VPWR VPWR _0874_ sky130_fd_sc_hd__inv_2
X_3306_ _1369_ _1370_ _1372_ _1368_ net246 VGND VGND VPWR VPWR _0240_ sky130_fd_sc_hd__a32o_1
XTAP_230 VGND VPWR sky130_fd_sc_hd__tapvpwrvgnd_1
XTAP_241 VGND VPWR sky130_fd_sc_hd__tapvpwrvgnd_1
X_3168_ net235 VGND VGND VPWR VPWR _1283_ sky130_fd_sc_hd__clkbuf_1
X_3237_ _0670_ _1315_ VGND VGND VPWR VPWR _1324_ sky130_fd_sc_hd__nand2_1
XTAP_296 VGND VPWR sky130_fd_sc_hd__tapvpwrvgnd_1
XTAP_285 VGND VPWR sky130_fd_sc_hd__tapvpwrvgnd_1
XTAP_274 VGND VPWR sky130_fd_sc_hd__tapvpwrvgnd_1
XTAP_263 VGND VPWR sky130_fd_sc_hd__tapvpwrvgnd_1
X_2119_ net98 _0323_ _0331_ _0321_ VGND VGND VPWR VPWR _0094_ sky130_fd_sc_hd__o211a_1
XTAP_252 VGND VPWR sky130_fd_sc_hd__tapvpwrvgnd_1
X_3099_ _1176_ _1239_ _1241_ _0970_ VGND VGND VPWR VPWR _0164_ sky130_fd_sc_hd__a22o_1
XFILLER_0_44_193 VGND VGND VPWR VPWR sky130_fd_sc_hd__decap_3
XFILLER_0_19_19 VPWR VGND VPWR VGND sky130_ef_sc_hd__decap_12
X_2470_ _0576_ _0655_ _0657_ _0658_ VGND VGND VPWR VPWR _0659_ sky130_fd_sc_hd__a31oi_1
X_3022_ _1153_ _1184_ VGND VGND VPWR VPWR _1187_ sky130_fd_sc_hd__and2b_1
X_2806_ RX.baud_cnt\[24\] _0723_ _1625_ _0981_ VGND VGND VPWR VPWR _0983_ sky130_fd_sc_hd__a2bb2o_1
X_2737_ RX.baud_cnt\[9\] _0383_ _0386_ RX.baud_cnt\[10\] VGND VGND VPWR VPWR _0914_
+ sky130_fd_sc_hd__a22o_1
X_2668_ _0799_ _0853_ _0856_ VGND VGND VPWR VPWR _0857_ sky130_fd_sc_hd__a21o_1
X_2599_ TX.baud_counter\[23\] _0786_ _0779_ TX.baud_counter\[22\] VGND VGND VPWR VPWR
+ _0788_ sky130_fd_sc_hd__a22oi_1
XFILLER_0_32_141 VGND VGND VPWR VPWR sky130_fd_sc_hd__fill_1
XFILLER_0_20_325 VGND VGND VPWR VPWR sky130_fd_sc_hd__fill_1
X_1970_ _1646_ RX.rx_shifter\[7\] _1649_ uart_rdr\[7\] VGND VGND VPWR VPWR _1665_
+ sky130_fd_sc_hd__a22o_1
X_3640_ clknet_leaf_4_S_AXI_ACLK _0205_ VGND VGND VPWR VPWR RX.uart_cpb\[30\] sky130_fd_sc_hd__dfxtp_1
X_2522_ _0709_ _0710_ _0707_ VGND VGND VPWR VPWR _0711_ sky130_fd_sc_hd__a21o_1
X_3571_ clknet_leaf_16_S_AXI_ACLK _0136_ net151 VGND VGND VPWR VPWR RX.baud_cnt\[4\]
+ sky130_fd_sc_hd__dfrtp_4
XFILLER_0_23_174 VGND VGND VPWR VPWR sky130_fd_sc_hd__fill_2
XFILLER_0_46_7 VGND VGND VPWR VPWR sky130_fd_sc_hd__decap_6
X_2384_ _0571_ _0572_ VGND VGND VPWR VPWR _0573_ sky130_fd_sc_hd__nand2_1
X_2453_ _0516_ _0517_ _0614_ _0589_ VGND VGND VPWR VPWR _0642_ sky130_fd_sc_hd__a31o_1
Xinput2 S_AXI_ARADDR[10] VGND VGND VPWR VPWR net2 sky130_fd_sc_hd__clkbuf_1
XFILLER_0_36_94 VGND VGND VPWR VPWR sky130_fd_sc_hd__fill_1
XFILLER_0_36_72 VGND VGND VPWR VPWR sky130_fd_sc_hd__fill_1
X_3005_ _1159_ _1173_ _1174_ _1154_ RX.baud_cnt\[5\] VGND VGND VPWR VPWR _0137_ sky130_fd_sc_hd__a32o_1
XFILLER_0_6_363 VGND VGND VPWR VPWR sky130_fd_sc_hd__fill_1
X_1884_ _1571_ net177 _1561_ _1599_ VGND VGND VPWR VPWR _0026_ sky130_fd_sc_hd__o211a_1
X_1953_ _1653_ VGND VGND VPWR VPWR _0041_ sky130_fd_sc_hd__clkbuf_1
XFILLER_0_22_85 VGND VGND VPWR VPWR sky130_fd_sc_hd__fill_2
X_3623_ clknet_leaf_3_S_AXI_ACLK _0188_ net155 VGND VGND VPWR VPWR RX.rx_shifter\[21\]
+ sky130_fd_sc_hd__dfrtp_1
X_3485_ clknet_leaf_9_S_AXI_ACLK _0050_ VGND VGND VPWR VPWR uart_rdr\[10\] sky130_fd_sc_hd__dfxtp_1
X_2505_ _0563_ _0564_ VGND VGND VPWR VPWR _0694_ sky130_fd_sc_hd__or2_1
X_3554_ clknet_leaf_10_S_AXI_ACLK _0119_ VGND VGND VPWR VPWR uart_cfg\[1\] sky130_fd_sc_hd__dfxtp_1
X_2298_ _1479_ _0494_ VGND VGND VPWR VPWR _0495_ sky130_fd_sc_hd__or2_1
X_2367_ _0343_ _0555_ VGND VGND VPWR VPWR _0556_ sky130_fd_sc_hd__nand2_1
X_2436_ _0520_ _0521_ VGND VGND VPWR VPWR _0625_ sky130_fd_sc_hd__or2_1
XPHY_106 VGND VGND VPWR VPWR sky130_fd_sc_hd__decap_3
XFILLER_0_19_244 VGND VGND VPWR VPWR sky130_fd_sc_hd__fill_2
XPHY_8 VGND VGND VPWR VPWR sky130_fd_sc_hd__decap_3
XFILLER_0_0_303 VGND VGND VPWR VPWR sky130_fd_sc_hd__fill_1
X_2221_ RX.uart_cpb\[25\] RX.uart_cpb\[24\] _0429_ VGND VGND VPWR VPWR _0432_ sky130_fd_sc_hd__or3_1
X_3270_ _0872_ _1345_ _1344_ VGND VGND VPWR VPWR _1346_ sky130_fd_sc_hd__a21bo_1
X_2152_ RX.uart_cpb\[1\] RX.uart_cpb\[0\] VGND VGND VPWR VPWR _0363_ sky130_fd_sc_hd__xor2_2
XFILLER_0_48_306 VGND VGND VPWR VPWR sky130_fd_sc_hd__fill_2
XFILLER_0_33_40 VGND VGND VPWR VPWR sky130_fd_sc_hd__fill_2
X_2083_ _0288_ _0307_ VGND VGND VPWR VPWR _0310_ sky130_fd_sc_hd__nor2_2
X_1867_ TX.uart_tdr\[15\] _1566_ _1567_ RX.uart_stp\[15\] VGND VGND VPWR VPWR _1586_
+ sky130_fd_sc_hd__a22o_1
X_1936_ TX.uart_tdr\[30\] _1506_ _1508_ RX.uart_stp\[30\] VGND VGND VPWR VPWR _1640_
+ sky130_fd_sc_hd__a22o_1
X_2985_ _0974_ VGND VGND VPWR VPWR _1160_ sky130_fd_sc_hd__clkbuf_4
XFILLER_0_16_225 VGND VGND VPWR VPWR sky130_fd_sc_hd__decap_8
Xinput93 S_AXI_WDATA[30] VGND VGND VPWR VPWR net93 sky130_fd_sc_hd__clkbuf_2
X_3537_ clknet_leaf_0_S_AXI_ACLK _0102_ VGND VGND VPWR VPWR TX.uart_tdr\[16\] sky130_fd_sc_hd__dfxtp_1
X_3468_ clknet_leaf_1_S_AXI_ACLK _0033_ VGND VGND VPWR VPWR net128 sky130_fd_sc_hd__dfxtp_1
X_1798_ uart_rdr\[2\] _1512_ _1494_ VGND VGND VPWR VPWR _1530_ sky130_fd_sc_hd__a21bo_1
X_3606_ clknet_leaf_10_S_AXI_ACLK _0171_ net160 VGND VGND VPWR VPWR RX.rx_shifter\[4\]
+ sky130_fd_sc_hd__dfrtp_1
Xinput71 S_AXI_WDATA[10] VGND VGND VPWR VPWR net71 sky130_fd_sc_hd__clkbuf_2
Xinput82 S_AXI_WDATA[20] VGND VGND VPWR VPWR net82 sky130_fd_sc_hd__clkbuf_2
Xinput60 S_AXI_AWADDR[3] VGND VGND VPWR VPWR net60 sky130_fd_sc_hd__dlymetal6s2s_1
X_2419_ _0523_ _0524_ VGND VGND VPWR VPWR _0608_ sky130_fd_sc_hd__nand2_1
X_3399_ TX.tx_enable _1352_ VGND VGND VPWR VPWR _1440_ sky130_fd_sc_hd__nand2_4
XFILLER_0_54_309 VPWR VGND VPWR VGND sky130_ef_sc_hd__decap_12
XFILLER_0_39_328 VGND VGND VPWR VPWR sky130_fd_sc_hd__fill_1
XFILLER_0_30_250 VGND VGND VPWR VPWR sky130_fd_sc_hd__fill_2
X_1721_ TX.bit_index\[2\] _1462_ _1463_ VGND VGND VPWR VPWR _1464_ sky130_fd_sc_hd__a21o_1
X_2770_ _0938_ _0939_ _0946_ _0940_ VGND VGND VPWR VPWR _0947_ sky130_fd_sc_hd__a31o_1
XTAP_423 VGND VPWR sky130_fd_sc_hd__tapvpwrvgnd_1
XTAP_412 VGND VPWR sky130_fd_sc_hd__tapvpwrvgnd_1
Xhold107 net117 VGND VGND VPWR VPWR net274 sky130_fd_sc_hd__dlygate4sd3_1
XTAP_401 VGND VPWR sky130_fd_sc_hd__tapvpwrvgnd_1
XFILLER_0_0_166 VGND VGND VPWR VPWR sky130_fd_sc_hd__fill_2
X_3322_ TX.baud_counter\[10\] TX.baud_counter\[9\] _1376_ TX.baud_counter\[11\] VGND
+ VGND VPWR VPWR _1384_ sky130_fd_sc_hd__a31o_1
Xhold118 TX.baud_counter\[14\] VGND VGND VPWR VPWR net285 sky130_fd_sc_hd__dlygate4sd3_1
Xhold129 TX.baud_counter\[9\] VGND VGND VPWR VPWR net296 sky130_fd_sc_hd__dlygate4sd3_1
XTAP_467 VGND VPWR sky130_fd_sc_hd__tapvpwrvgnd_1
XTAP_456 VGND VPWR sky130_fd_sc_hd__tapvpwrvgnd_1
XTAP_445 VGND VPWR sky130_fd_sc_hd__tapvpwrvgnd_1
XTAP_434 VGND VPWR sky130_fd_sc_hd__tapvpwrvgnd_1
X_3253_ net89 _1328_ _1333_ _1322_ VGND VGND VPWR VPWR _0226_ sky130_fd_sc_hd__o211a_1
X_3184_ _1291_ VGND VGND VPWR VPWR _1292_ sky130_fd_sc_hd__buf_2
XFILLER_0_28_40 VGND VGND VPWR VPWR sky130_fd_sc_hd__fill_1
X_2204_ TX.baud_counter\[16\] _0409_ _0414_ TX.baud_counter\[17\] VGND VGND VPWR VPWR
+ _0415_ sky130_fd_sc_hd__a22o_1
XFILLER_0_21_6 VGND VGND VPWR VPWR sky130_fd_sc_hd__fill_1
X_2135_ RX.uart_cpb\[21\] _0344_ RX.uart_cpb\[22\] VGND VGND VPWR VPWR _0346_ sky130_fd_sc_hd__o21ai_1
X_2066_ net92 _0291_ _0298_ VGND VGND VPWR VPWR _0074_ sky130_fd_sc_hd__a21o_1
X_1919_ uart_rdr\[26\] _1513_ _1494_ VGND VGND VPWR VPWR _1627_ sky130_fd_sc_hd__a21bo_1
X_2968_ _1135_ _1143_ _1144_ VGND VGND VPWR VPWR _1145_ sky130_fd_sc_hd__a21bo_1
X_2899_ RX.baud_cnt\[14\] _0845_ VGND VGND VPWR VPWR _1076_ sky130_fd_sc_hd__nor2_1
XFILLER_0_12_250 VGND VGND VPWR VPWR sky130_fd_sc_hd__fill_2
XFILLER_0_54_139 VGND VGND VPWR VPWR sky130_fd_sc_hd__fill_1
XFILLER_0_38_191 VGND VGND VPWR VPWR sky130_fd_sc_hd__decap_4
X_2822_ _0352_ _0904_ _0998_ RX.uart_cpb\[19\] VGND VGND VPWR VPWR _0999_ sky130_fd_sc_hd__a2bb2o_1
X_2684_ TX.state\[1\] TX.state\[0\] VGND VGND VPWR VPWR _0873_ sky130_fd_sc_hd__nand2_1
X_2753_ _0921_ _0928_ _0929_ VGND VGND VPWR VPWR _0930_ sky130_fd_sc_hd__a21o_1
XTAP_275 VGND VPWR sky130_fd_sc_hd__tapvpwrvgnd_1
XTAP_264 VGND VPWR sky130_fd_sc_hd__tapvpwrvgnd_1
X_3305_ _1353_ _1371_ VGND VGND VPWR VPWR _1372_ sky130_fd_sc_hd__nor2_1
XTAP_220 VGND VPWR sky130_fd_sc_hd__tapvpwrvgnd_1
XTAP_231 VGND VPWR sky130_fd_sc_hd__tapvpwrvgnd_1
XTAP_242 VGND VPWR sky130_fd_sc_hd__tapvpwrvgnd_1
XTAP_253 VGND VPWR sky130_fd_sc_hd__tapvpwrvgnd_1
X_3167_ _1282_ VGND VGND VPWR VPWR _0191_ sky130_fd_sc_hd__clkbuf_1
X_2049_ _1700_ _0284_ VGND VGND VPWR VPWR _0285_ sky130_fd_sc_hd__and2_1
X_3098_ _1176_ _1240_ VGND VGND VPWR VPWR _1241_ sky130_fd_sc_hd__nand2_1
X_3236_ net73 _1318_ _1323_ _1322_ VGND VGND VPWR VPWR _0219_ sky130_fd_sc_hd__o211a_1
XTAP_297 VGND VPWR sky130_fd_sc_hd__tapvpwrvgnd_1
XTAP_286 VGND VPWR sky130_fd_sc_hd__tapvpwrvgnd_1
X_2118_ TX.data_latch_next\[6\] _0324_ VGND VGND VPWR VPWR _0331_ sky130_fd_sc_hd__or2_1
XFILLER_0_27_139 VGND VGND VPWR VPWR sky130_fd_sc_hd__fill_2
XFILLER_0_25_30 VGND VGND VPWR VPWR sky130_fd_sc_hd__fill_1
X_3021_ _1159_ _1183_ _1185_ _1186_ RX.baud_cnt\[9\] VGND VGND VPWR VPWR _0141_ sky130_fd_sc_hd__a32o_1
X_2805_ _1625_ _0981_ VGND VGND VPWR VPWR _0982_ sky130_fd_sc_hd__nor2_1
XFILLER_0_26_161 VGND VGND VPWR VPWR sky130_fd_sc_hd__fill_1
X_2736_ RX.baud_cnt\[10\] _0386_ _0390_ RX.baud_cnt\[11\] VGND VGND VPWR VPWR _0913_
+ sky130_fd_sc_hd__o22a_1
X_2667_ TX.baud_counter\[19\] _0790_ _0796_ TX.baud_counter\[18\] VGND VGND VPWR VPWR
+ _0856_ sky130_fd_sc_hd__a22o_1
X_3219_ net84 _1305_ _1312_ _1302_ VGND VGND VPWR VPWR _0213_ sky130_fd_sc_hd__o211a_1
X_2598_ TX.baud_counter\[23\] _0786_ VGND VGND VPWR VPWR _0787_ sky130_fd_sc_hd__or2_1
XFILLER_0_17_150 VGND VGND VPWR VPWR sky130_fd_sc_hd__decap_4
XFILLER_0_32_186 VGND VGND VPWR VPWR sky130_fd_sc_hd__fill_2
XFILLER_0_32_175 VGND VGND VPWR VPWR sky130_fd_sc_hd__decap_6
XFILLER_0_46_29 VGND VGND VPWR VPWR sky130_fd_sc_hd__fill_1
XFILLER_0_55_245 VGND VGND VPWR VPWR sky130_fd_sc_hd__fill_2
X_2521_ _0509_ _0708_ _0571_ _0507_ VGND VGND VPWR VPWR _0710_ sky130_fd_sc_hd__o211a_1
X_3570_ clknet_leaf_19_S_AXI_ACLK _0135_ net151 VGND VGND VPWR VPWR RX.baud_cnt\[3\]
+ sky130_fd_sc_hd__dfrtp_1
XFILLER_0_11_21 VGND VGND VPWR VPWR sky130_fd_sc_hd__fill_1
XFILLER_0_11_65 VGND VGND VPWR VPWR sky130_fd_sc_hd__fill_1
XFILLER_0_23_120 VGND VGND VPWR VPWR sky130_fd_sc_hd__fill_2
X_2383_ RX.uart_cpb\[23\] RX.uart_cpb\[24\] VGND VGND VPWR VPWR _0572_ sky130_fd_sc_hd__or2_1
X_2452_ _0516_ _0614_ _0517_ VGND VGND VPWR VPWR _0641_ sky130_fd_sc_hd__a21oi_1
Xinput3 S_AXI_ARADDR[11] VGND VGND VPWR VPWR net3 sky130_fd_sc_hd__buf_1
X_3004_ RX.baud_cnt\[5\] _1171_ _1163_ VGND VGND VPWR VPWR _1174_ sky130_fd_sc_hd__o21a_1
X_3699_ clknet_leaf_18_S_AXI_ACLK _0264_ net152 VGND VGND VPWR VPWR TX.baud_counter\[30\]
+ sky130_fd_sc_hd__dfrtp_2
XFILLER_0_14_197 VGND VGND VPWR VPWR sky130_fd_sc_hd__fill_2
X_2719_ _0895_ _0349_ VGND VGND VPWR VPWR _0896_ sky130_fd_sc_hd__nand2_1
X_3622_ clknet_leaf_3_S_AXI_ACLK _0187_ net162 VGND VGND VPWR VPWR RX.rx_shifter\[20\]
+ sky130_fd_sc_hd__dfrtp_1
X_1883_ _1596_ _1578_ _1597_ _1598_ VGND VGND VPWR VPWR _1599_ sky130_fd_sc_hd__a211o_1
X_1952_ _1635_ _1652_ VGND VGND VPWR VPWR _1653_ sky130_fd_sc_hd__and2_1
X_3484_ clknet_leaf_9_S_AXI_ACLK _0049_ VGND VGND VPWR VPWR uart_rdr\[9\] sky130_fd_sc_hd__dfxtp_1
X_2504_ _0570_ _0589_ _0691_ _0692_ VGND VGND VPWR VPWR _0693_ sky130_fd_sc_hd__o31a_1
X_3553_ clknet_leaf_12_S_AXI_ACLK _0118_ VGND VGND VPWR VPWR TX.tx_enable sky130_fd_sc_hd__dfxtp_2
XFILLER_0_3_345 VGND VGND VPWR VPWR sky130_fd_sc_hd__fill_1
X_2435_ _0621_ _0622_ _0623_ VGND VGND VPWR VPWR _0624_ sky130_fd_sc_hd__o21bai_2
Xclkbuf_leaf_18_S_AXI_ACLK clknet_1_0__leaf_S_AXI_ACLK VGND VGND VPWR VPWR clknet_leaf_18_S_AXI_ACLK
+ sky130_fd_sc_hd__clkbuf_16
XFILLER_0_11_167 VGND VGND VPWR VPWR sky130_fd_sc_hd__fill_1
X_2297_ net103 net109 VGND VGND VPWR VPWR _0494_ sky130_fd_sc_hd__nand2_2
X_2366_ RX.uart_cpb\[19\] _1596_ VGND VGND VPWR VPWR _0555_ sky130_fd_sc_hd__nand2_1
XFILLER_0_2_41 VGND VGND VPWR VPWR sky130_fd_sc_hd__decap_4
XPHY_107 VGND VGND VPWR VPWR sky130_fd_sc_hd__decap_3
XFILLER_0_2_85 VGND VGND VPWR VPWR sky130_fd_sc_hd__fill_2
XFILLER_0_57_307 VGND VGND VPWR VPWR sky130_fd_sc_hd__fill_1
XPHY_9 VGND VGND VPWR VPWR sky130_fd_sc_hd__decap_3
XFILLER_0_57_329 VGND VGND VPWR VPWR sky130_fd_sc_hd__decap_6
XFILLER_0_0_337 VGND VGND VPWR VPWR sky130_fd_sc_hd__fill_2
XFILLER_0_0_315 VGND VGND VPWR VPWR sky130_fd_sc_hd__decap_3
X_2082_ _0308_ VGND VGND VPWR VPWR _0309_ sky130_fd_sc_hd__buf_2
X_2151_ _1535_ _0361_ _0334_ VGND VGND VPWR VPWR _0362_ sky130_fd_sc_hd__a21boi_2
X_2220_ TX.baud_counter\[24\] _0430_ _0349_ TX.baud_counter\[23\] VGND VGND VPWR VPWR
+ _0431_ sky130_fd_sc_hd__o22a_1
XFILLER_0_33_85 VGND VGND VPWR VPWR sky130_fd_sc_hd__decap_3
X_2984_ _1158_ VGND VGND VPWR VPWR _1159_ sky130_fd_sc_hd__buf_2
XFILLER_0_56_351 VGND VGND VPWR VPWR sky130_fd_sc_hd__decap_4
Xinput50 S_AXI_AWADDR[23] VGND VGND VPWR VPWR net50 sky130_fd_sc_hd__buf_1
X_1866_ _1571_ net183 _1561_ _1585_ VGND VGND VPWR VPWR _0022_ sky130_fd_sc_hd__o211a_1
X_1935_ RX.uart_cpb\[30\] VGND VGND VPWR VPWR _1639_ sky130_fd_sc_hd__buf_2
X_3605_ clknet_leaf_10_S_AXI_ACLK _0170_ net160 VGND VGND VPWR VPWR RX.rx_shifter\[3\]
+ sky130_fd_sc_hd__dfrtp_1
Xinput72 S_AXI_WDATA[11] VGND VGND VPWR VPWR net72 sky130_fd_sc_hd__clkbuf_2
Xinput61 S_AXI_AWADDR[4] VGND VGND VPWR VPWR net61 sky130_fd_sc_hd__dlymetal6s2s_1
X_1797_ _1495_ net122 _1528_ _1529_ _1524_ VGND VGND VPWR VPWR _0009_ sky130_fd_sc_hd__o221a_1
X_3467_ clknet_leaf_2_S_AXI_ACLK _0032_ VGND VGND VPWR VPWR net127 sky130_fd_sc_hd__dfxtp_1
Xinput94 S_AXI_WDATA[31] VGND VGND VPWR VPWR net94 sky130_fd_sc_hd__clkbuf_2
Xinput83 S_AXI_WDATA[21] VGND VGND VPWR VPWR net83 sky130_fd_sc_hd__clkbuf_2
X_2418_ _1545_ _1541_ VGND VGND VPWR VPWR _0607_ sky130_fd_sc_hd__nand2_1
X_3536_ clknet_leaf_14_S_AXI_ACLK net188 VGND VGND VPWR VPWR net110 sky130_fd_sc_hd__dfxtp_1
X_3398_ _1342_ _1348_ _1439_ _1343_ TX.baud_counter\[31\] VGND VGND VPWR VPWR _0265_
+ sky130_fd_sc_hd__a32o_1
X_2349_ RX.uart_cpb\[14\] RX.uart_cpb\[13\] VGND VGND VPWR VPWR _0538_ sky130_fd_sc_hd__nand2_1
XFILLER_0_39_318 VGND VGND VPWR VPWR sky130_fd_sc_hd__fill_2
XFILLER_0_54_29 VPWR VGND VPWR VGND sky130_ef_sc_hd__decap_12
XFILLER_0_53_321 VPWR VGND VPWR VGND sky130_ef_sc_hd__decap_12
X_1720_ TX.state\[0\] TX.state\[1\] VGND VGND VPWR VPWR _1463_ sky130_fd_sc_hd__or2b_2
Xhold108 TX.baud_counter\[17\] VGND VGND VPWR VPWR net275 sky130_fd_sc_hd__dlygate4sd3_1
XTAP_457 VGND VPWR sky130_fd_sc_hd__tapvpwrvgnd_1
XTAP_446 VGND VPWR sky130_fd_sc_hd__tapvpwrvgnd_1
XTAP_435 VGND VPWR sky130_fd_sc_hd__tapvpwrvgnd_1
XTAP_424 VGND VPWR sky130_fd_sc_hd__tapvpwrvgnd_1
XTAP_413 VGND VPWR sky130_fd_sc_hd__tapvpwrvgnd_1
XTAP_402 VGND VPWR sky130_fd_sc_hd__tapvpwrvgnd_1
X_3252_ net282 _1329_ VGND VGND VPWR VPWR _1333_ sky130_fd_sc_hd__or2_1
X_3321_ TX.baud_counter\[10\] _1355_ _1350_ _1383_ VGND VGND VPWR VPWR _0244_ sky130_fd_sc_hd__a22o_1
Xhold119 TX.baud_counter\[23\] VGND VGND VPWR VPWR net286 sky130_fd_sc_hd__dlygate4sd3_1
XTAP_468 VGND VPWR sky130_fd_sc_hd__tapvpwrvgnd_1
X_3183_ _1290_ VGND VGND VPWR VPWR _1291_ sky130_fd_sc_hd__clkbuf_2
X_2203_ _0412_ _0413_ VGND VGND VPWR VPWR _0414_ sky130_fd_sc_hd__nor2_2
XFILLER_0_28_85 VGND VGND VPWR VPWR sky130_fd_sc_hd__decap_4
XFILLER_0_28_52 VGND VGND VPWR VPWR sky130_fd_sc_hd__decap_6
X_2134_ RX.uart_cpb\[22\] RX.uart_cpb\[21\] _0344_ VGND VGND VPWR VPWR _0345_ sky130_fd_sc_hd__or3_2
X_2065_ _0297_ _0291_ _1635_ VGND VGND VPWR VPWR _0298_ sky130_fd_sc_hd__o21ai_1
XFILLER_0_14_6 VGND VGND VPWR VPWR sky130_fd_sc_hd__decap_6
XFILLER_0_56_192 VGND VGND VPWR VPWR sky130_fd_sc_hd__fill_1
XFILLER_0_56_170 VGND VGND VPWR VPWR sky130_fd_sc_hd__fill_2
Xclkbuf_leaf_8_S_AXI_ACLK clknet_1_1__leaf_S_AXI_ACLK VGND VGND VPWR VPWR clknet_leaf_8_S_AXI_ACLK
+ sky130_fd_sc_hd__clkbuf_16
XFILLER_0_48_159 VGND VGND VPWR VPWR sky130_fd_sc_hd__decap_4
XFILLER_0_44_332 VGND VGND VPWR VPWR sky130_fd_sc_hd__fill_2
X_2967_ RX.baud_cnt\[30\] _0767_ _0766_ RX.baud_cnt\[31\] VGND VGND VPWR VPWR _1144_
+ sky130_fd_sc_hd__o22a_1
X_1918_ TX.uart_tdr\[26\] _1604_ _1605_ RX.uart_stp\[26\] VGND VGND VPWR VPWR _1626_
+ sky130_fd_sc_hd__a22o_1
X_1849_ TX.uart_tdr\[11\] _1566_ _1567_ RX.uart_stp\[11\] VGND VGND VPWR VPWR _1572_
+ sky130_fd_sc_hd__a22o_1
XFILLER_0_44_354 VGND VGND VPWR VPWR sky130_fd_sc_hd__fill_1
X_2898_ _1072_ _1073_ _1074_ VGND VGND VPWR VPWR _1075_ sky130_fd_sc_hd__o21a_1
XFILLER_0_5_9 VPWR VGND VPWR VGND sky130_ef_sc_hd__decap_12
X_3519_ clknet_leaf_14_S_AXI_ACLK _0084_ VGND VGND VPWR VPWR RX.uart_stp\[4\] sky130_fd_sc_hd__dfxtp_1
XFILLER_0_14_21 VGND VGND VPWR VPWR sky130_fd_sc_hd__fill_2
XFILLER_0_14_65 VGND VGND VPWR VPWR sky130_fd_sc_hd__decap_4
X_2821_ RX.baud_cnt\[18\] VGND VGND VPWR VPWR _0998_ sky130_fd_sc_hd__inv_2
XFILLER_0_41_335 VGND VGND VPWR VPWR sky130_fd_sc_hd__fill_1
X_2752_ RX.baud_cnt\[5\] _0358_ _0372_ RX.baud_cnt\[6\] VGND VGND VPWR VPWR _0929_
+ sky130_fd_sc_hd__a22o_1
X_2683_ TX.baud_counter\[31\] _0766_ _0768_ _0871_ VGND VGND VPWR VPWR _0872_ sky130_fd_sc_hd__o22ai_4
X_3235_ _0392_ _1315_ VGND VGND VPWR VPWR _1323_ sky130_fd_sc_hd__nand2_1
XTAP_298 VGND VPWR sky130_fd_sc_hd__tapvpwrvgnd_1
XTAP_287 VGND VPWR sky130_fd_sc_hd__tapvpwrvgnd_1
XTAP_276 VGND VPWR sky130_fd_sc_hd__tapvpwrvgnd_1
XTAP_265 VGND VPWR sky130_fd_sc_hd__tapvpwrvgnd_1
X_3304_ TX.baud_counter\[6\] _1366_ VGND VGND VPWR VPWR _1371_ sky130_fd_sc_hd__and2_1
XTAP_210 VGND VPWR sky130_fd_sc_hd__tapvpwrvgnd_1
XTAP_221 VGND VPWR sky130_fd_sc_hd__tapvpwrvgnd_1
XTAP_232 VGND VPWR sky130_fd_sc_hd__tapvpwrvgnd_1
XTAP_243 VGND VPWR sky130_fd_sc_hd__tapvpwrvgnd_1
XTAP_254 VGND VPWR sky130_fd_sc_hd__tapvpwrvgnd_1
X_3166_ net216 VGND VGND VPWR VPWR _1282_ sky130_fd_sc_hd__clkbuf_1
X_2048_ RX.done_reg RX.rx_shifter\[31\] _1648_ uart_rdr\[31\] VGND VGND VPWR VPWR
+ _0284_ sky130_fd_sc_hd__a22o_1
X_3097_ _0972_ _1238_ VGND VGND VPWR VPWR _1240_ sky130_fd_sc_hd__or2_1
X_2117_ net97 _0323_ _0330_ _0321_ VGND VGND VPWR VPWR _0093_ sky130_fd_sc_hd__o211a_1
XFILLER_0_32_346 VGND VGND VPWR VPWR sky130_fd_sc_hd__fill_2
XFILLER_0_27_118 VGND VGND VPWR VPWR sky130_fd_sc_hd__decap_6
XFILLER_0_35_184 VGND VGND VPWR VPWR sky130_fd_sc_hd__fill_1
XFILLER_0_25_53 VGND VGND VPWR VPWR sky130_fd_sc_hd__decap_3
X_3020_ _1153_ VGND VGND VPWR VPWR _1186_ sky130_fd_sc_hd__clkbuf_4
X_2804_ RX.baud_cnt\[25\] VGND VGND VPWR VPWR _0981_ sky130_fd_sc_hd__inv_2
XFILLER_0_41_110 VGND VGND VPWR VPWR sky130_fd_sc_hd__fill_2
X_2597_ _0704_ _0785_ VGND VGND VPWR VPWR _0786_ sky130_fd_sc_hd__nor2_1
XFILLER_0_26_195 VGND VGND VPWR VPWR sky130_fd_sc_hd__fill_1
X_2666_ _0853_ _0854_ VGND VGND VPWR VPWR _0855_ sky130_fd_sc_hd__nor2_1
X_2735_ RX.baud_cnt\[11\] _0390_ _0393_ RX.baud_cnt\[12\] VGND VGND VPWR VPWR _0912_
+ sky130_fd_sc_hd__a22o_1
X_3149_ _1273_ VGND VGND VPWR VPWR _0182_ sky130_fd_sc_hd__clkbuf_1
X_3218_ _0579_ _1304_ VGND VGND VPWR VPWR _1312_ sky130_fd_sc_hd__nand2_1
X_2520_ _0560_ _0562_ _0566_ _0708_ VGND VGND VPWR VPWR _0709_ sky130_fd_sc_hd__a211o_1
XFILLER_0_11_316 VGND VGND VPWR VPWR sky130_fd_sc_hd__fill_1
X_2451_ _0612_ _0617_ _0639_ VGND VGND VPWR VPWR _0640_ sky130_fd_sc_hd__and3b_2
Xinput4 S_AXI_ARADDR[12] VGND VGND VPWR VPWR net4 sky130_fd_sc_hd__buf_1
X_2382_ RX.uart_cpb\[23\] RX.uart_cpb\[24\] VGND VGND VPWR VPWR _0571_ sky130_fd_sc_hd__nand2_1
X_3003_ RX.baud_cnt\[5\] _1171_ VGND VGND VPWR VPWR _1173_ sky130_fd_sc_hd__nand2_1
XFILLER_0_36_85 VGND VGND VPWR VPWR sky130_fd_sc_hd__fill_1
X_2718_ RX.baud_cnt\[23\] VGND VGND VPWR VPWR _0895_ sky130_fd_sc_hd__clkbuf_4
X_3698_ clknet_leaf_18_S_AXI_ACLK _0263_ net153 VGND VGND VPWR VPWR TX.baud_counter\[29\]
+ sky130_fd_sc_hd__dfrtp_4
X_2649_ TX.baud_counter\[9\] _0807_ _0834_ _0835_ _0837_ VGND VGND VPWR VPWR _0838_
+ sky130_fd_sc_hd__o221a_1
XFILLER_0_37_279 VGND VGND VPWR VPWR sky130_fd_sc_hd__fill_1
XFILLER_0_57_29 VGND VGND VPWR VPWR sky130_fd_sc_hd__fill_2
XFILLER_0_28_213 VGND VGND VPWR VPWR sky130_fd_sc_hd__fill_1
X_3621_ clknet_leaf_7_S_AXI_ACLK _0186_ net159 VGND VGND VPWR VPWR RX.rx_shifter\[19\]
+ sky130_fd_sc_hd__dfrtp_1
X_1882_ uart_rdr\[18\] _1580_ _1590_ VGND VGND VPWR VPWR _1598_ sky130_fd_sc_hd__a21bo_1
X_3552_ clknet_leaf_6_S_AXI_ACLK _0117_ VGND VGND VPWR VPWR TX.uart_tdr\[15\] sky130_fd_sc_hd__dfxtp_1
XFILLER_0_43_249 VGND VGND VPWR VPWR sky130_fd_sc_hd__fill_1
X_1951_ _1646_ RX.rx_shifter\[1\] _1649_ uart_rdr\[1\] VGND VGND VPWR VPWR _1652_
+ sky130_fd_sc_hd__a22o_1
XFILLER_0_22_10 VGND VGND VPWR VPWR sky130_fd_sc_hd__fill_1
X_3483_ clknet_leaf_9_S_AXI_ACLK _0048_ VGND VGND VPWR VPWR uart_rdr\[8\] sky130_fd_sc_hd__dfxtp_1
X_2503_ _0350_ _0313_ _0604_ _0579_ VGND VGND VPWR VPWR _0692_ sky130_fd_sc_hd__o22a_1
X_2365_ _0552_ _0553_ VGND VGND VPWR VPWR _0554_ sky130_fd_sc_hd__or2_1
X_2434_ _0363_ _0575_ _0580_ _1522_ VGND VGND VPWR VPWR _0623_ sky130_fd_sc_hd__a22o_1
XFILLER_0_11_157 VGND VGND VPWR VPWR sky130_fd_sc_hd__fill_2
X_2296_ net85 _0483_ _0493_ _0487_ VGND VGND VPWR VPWR _0109_ sky130_fd_sc_hd__o211a_1
XFILLER_0_2_75 VGND VGND VPWR VPWR sky130_fd_sc_hd__fill_1
XPHY_108 VGND VGND VPWR VPWR sky130_fd_sc_hd__decap_3
XFILLER_0_2_97 VGND VGND VPWR VPWR sky130_fd_sc_hd__fill_2
X_2081_ _0288_ _0307_ VGND VGND VPWR VPWR _0308_ sky130_fd_sc_hd__or2_1
X_2150_ _1532_ RX.uart_cpb\[1\] _1522_ VGND VGND VPWR VPWR _0361_ sky130_fd_sc_hd__or3_1
X_1934_ _1609_ net196 _1635_ _1638_ VGND VGND VPWR VPWR _0037_ sky130_fd_sc_hd__o211a_1
XFILLER_0_33_97 VGND VGND VPWR VPWR sky130_fd_sc_hd__decap_8
X_2983_ _1152_ _1157_ VGND VGND VPWR VPWR _1158_ sky130_fd_sc_hd__nor2_2
Xinput51 S_AXI_AWADDR[24] VGND VGND VPWR VPWR net51 sky130_fd_sc_hd__clkbuf_1
Xinput62 S_AXI_AWADDR[5] VGND VGND VPWR VPWR net62 sky130_fd_sc_hd__clkbuf_1
Xinput95 S_AXI_WDATA[3] VGND VGND VPWR VPWR net95 sky130_fd_sc_hd__buf_2
X_1865_ RX.uart_cpb\[14\] _1578_ _1583_ _1584_ VGND VGND VPWR VPWR _1585_ sky130_fd_sc_hd__a211o_1
X_3535_ clknet_leaf_9_S_AXI_ACLK _0100_ VGND VGND VPWR VPWR net143 sky130_fd_sc_hd__dfxtp_1
X_3604_ clknet_leaf_9_S_AXI_ACLK _0169_ net160 VGND VGND VPWR VPWR RX.rx_shifter\[2\]
+ sky130_fd_sc_hd__dfrtp_1
XFILLER_0_24_293 VGND VGND VPWR VPWR sky130_fd_sc_hd__fill_1
X_1796_ uart_cfg\[1\] _1518_ _1520_ RX.uart_cpb\[1\] VGND VGND VPWR VPWR _1529_ sky130_fd_sc_hd__a22o_1
Xinput40 S_AXI_AWADDR[14] VGND VGND VPWR VPWR net40 sky130_fd_sc_hd__clkbuf_1
Xinput73 S_AXI_WDATA[12] VGND VGND VPWR VPWR net73 sky130_fd_sc_hd__clkbuf_2
Xinput84 S_AXI_WDATA[22] VGND VGND VPWR VPWR net84 sky130_fd_sc_hd__buf_1
X_3466_ clknet_leaf_2_S_AXI_ACLK _0031_ VGND VGND VPWR VPWR net126 sky130_fd_sc_hd__dfxtp_1
X_2348_ _0392_ _0535_ _0513_ _0536_ _0510_ VGND VGND VPWR VPWR _0537_ sky130_fd_sc_hd__o221a_1
X_3397_ TX.baud_counter\[31\] _1437_ VGND VGND VPWR VPWR _1439_ sky130_fd_sc_hd__xor2_1
X_2417_ _0601_ _0602_ _0605_ VGND VGND VPWR VPWR _0606_ sky130_fd_sc_hd__o21a_1
X_2279_ _1479_ _0481_ VGND VGND VPWR VPWR _0484_ sky130_fd_sc_hd__nor2_2
XFILLER_0_47_352 VGND VGND VPWR VPWR sky130_fd_sc_hd__fill_1
XFILLER_0_53_333 VGND VGND VPWR VPWR sky130_fd_sc_hd__decap_3
Xhold109 net111 VGND VGND VPWR VPWR net276 sky130_fd_sc_hd__dlygate4sd3_1
XTAP_469 VGND VPWR sky130_fd_sc_hd__tapvpwrvgnd_1
XTAP_458 VGND VPWR sky130_fd_sc_hd__tapvpwrvgnd_1
XTAP_447 VGND VPWR sky130_fd_sc_hd__tapvpwrvgnd_1
XTAP_436 VGND VPWR sky130_fd_sc_hd__tapvpwrvgnd_1
XTAP_425 VGND VPWR sky130_fd_sc_hd__tapvpwrvgnd_1
XTAP_414 VGND VPWR sky130_fd_sc_hd__tapvpwrvgnd_1
XTAP_403 VGND VPWR sky130_fd_sc_hd__tapvpwrvgnd_1
X_3251_ net88 _1328_ _1332_ _1322_ VGND VGND VPWR VPWR _0225_ sky130_fd_sc_hd__o211a_1
X_3182_ _1480_ _0287_ VGND VGND VPWR VPWR _1290_ sky130_fd_sc_hd__or2_1
X_2202_ RX.uart_cpb\[16\] _0341_ RX.uart_cpb\[17\] VGND VGND VPWR VPWR _0413_ sky130_fd_sc_hd__o21a_1
XFILLER_0_0_113 VGND VGND VPWR VPWR sky130_fd_sc_hd__fill_1
X_3320_ TX.baud_counter\[10\] _1379_ _1382_ VGND VGND VPWR VPWR _1383_ sky130_fd_sc_hd__o21a_1
XFILLER_0_21_241 VGND VGND VPWR VPWR sky130_fd_sc_hd__fill_2
X_2133_ RX.uart_cpb\[20\] _0341_ _0342_ _0343_ VGND VGND VPWR VPWR _0344_ sky130_fd_sc_hd__or4_2
X_2064_ _1532_ VGND VGND VPWR VPWR _0297_ sky130_fd_sc_hd__inv_2
X_1917_ RX.uart_cpb\[26\] VGND VGND VPWR VPWR _1625_ sky130_fd_sc_hd__buf_2
X_2966_ _1129_ _1133_ _1142_ VGND VGND VPWR VPWR _1143_ sky130_fd_sc_hd__or3_1
XFILLER_0_29_363 VGND VGND VPWR VPWR sky130_fd_sc_hd__fill_1
X_2897_ RX.baud_cnt\[7\] _0829_ VGND VGND VPWR VPWR _1074_ sky130_fd_sc_hd__or2_1
X_1848_ _1495_ VGND VGND VPWR VPWR _1571_ sky130_fd_sc_hd__clkbuf_4
X_1779_ _1512_ VGND VGND VPWR VPWR _1513_ sky130_fd_sc_hd__clkbuf_4
X_3518_ clknet_leaf_10_S_AXI_ACLK _0083_ VGND VGND VPWR VPWR RX.uart_stp\[3\] sky130_fd_sc_hd__dfxtp_1
XFILLER_0_8_85 VGND VGND VPWR VPWR sky130_fd_sc_hd__fill_1
X_3449_ clknet_leaf_14_S_AXI_ACLK _0014_ VGND VGND VPWR VPWR net139 sky130_fd_sc_hd__dfxtp_1
XFILLER_0_26_322 VGND VGND VPWR VPWR sky130_fd_sc_hd__fill_1
X_2820_ _0579_ RX.baud_cnt\[21\] RX.baud_cnt\[20\] _0350_ VGND VGND VPWR VPWR _0997_
+ sky130_fd_sc_hd__o22a_1
X_2751_ _0923_ _0926_ _0927_ VGND VGND VPWR VPWR _0928_ sky130_fd_sc_hd__a21o_1
XFILLER_0_41_325 VGND VGND VPWR VPWR sky130_fd_sc_hd__fill_2
X_2682_ TX.baud_counter\[29\] _0770_ _0772_ _0869_ _0870_ VGND VGND VPWR VPWR _0871_
+ sky130_fd_sc_hd__o221a_1
X_3165_ _1281_ VGND VGND VPWR VPWR _0190_ sky130_fd_sc_hd__clkbuf_1
X_3234_ net72 _1318_ _1321_ _1322_ VGND VGND VPWR VPWR _0218_ sky130_fd_sc_hd__o211a_1
XTAP_299 VGND VPWR sky130_fd_sc_hd__tapvpwrvgnd_1
XTAP_288 VGND VPWR sky130_fd_sc_hd__tapvpwrvgnd_1
XTAP_277 VGND VPWR sky130_fd_sc_hd__tapvpwrvgnd_1
XTAP_266 VGND VPWR sky130_fd_sc_hd__tapvpwrvgnd_1
X_3303_ TX.baud_counter\[6\] _1366_ VGND VGND VPWR VPWR _1370_ sky130_fd_sc_hd__or2_1
XTAP_200 VGND VPWR sky130_fd_sc_hd__tapvpwrvgnd_1
XTAP_211 VGND VPWR sky130_fd_sc_hd__tapvpwrvgnd_1
XTAP_222 VGND VPWR sky130_fd_sc_hd__tapvpwrvgnd_1
XTAP_233 VGND VPWR sky130_fd_sc_hd__tapvpwrvgnd_1
XTAP_244 VGND VPWR sky130_fd_sc_hd__tapvpwrvgnd_1
XTAP_255 VGND VPWR sky130_fd_sc_hd__tapvpwrvgnd_1
X_2047_ _0283_ VGND VGND VPWR VPWR _0070_ sky130_fd_sc_hd__clkbuf_1
X_3096_ _0970_ _1238_ VGND VGND VPWR VPWR _1239_ sky130_fd_sc_hd__nor2_1
X_2116_ net313 _0324_ VGND VGND VPWR VPWR _0330_ sky130_fd_sc_hd__or2_1
X_2949_ _0959_ _0866_ VGND VGND VPWR VPWR _1126_ sky130_fd_sc_hd__and2_1
XFILLER_0_35_152 VGND VGND VPWR VPWR sky130_fd_sc_hd__decap_4
XFILLER_0_26_185 VGND VGND VPWR VPWR sky130_fd_sc_hd__fill_2
XFILLER_0_26_141 VGND VGND VPWR VPWR sky130_fd_sc_hd__fill_1
X_2803_ _0441_ RX.baud_cnt\[26\] _0979_ _0978_ VGND VGND VPWR VPWR _0980_ sky130_fd_sc_hd__a211o_1
X_2734_ _0910_ _0398_ _0400_ RX.baud_cnt\[14\] VGND VGND VPWR VPWR _0911_ sky130_fd_sc_hd__a22oi_2
XFILLER_0_41_199 VGND VGND VPWR VPWR sky130_fd_sc_hd__decap_3
X_2596_ _0690_ _0702_ _0584_ VGND VGND VPWR VPWR _0785_ sky130_fd_sc_hd__a21oi_1
X_2665_ TX.baud_counter\[16\] _0852_ _0850_ TX.baud_counter\[15\] VGND VGND VPWR VPWR
+ _0854_ sky130_fd_sc_hd__o22ai_1
X_3148_ net198 VGND VGND VPWR VPWR _1273_ sky130_fd_sc_hd__clkbuf_1
X_3217_ net83 _1305_ _1311_ _1302_ VGND VGND VPWR VPWR _0212_ sky130_fd_sc_hd__o211a_1
XFILLER_0_9_363 VGND VGND VPWR VPWR sky130_fd_sc_hd__fill_1
X_3079_ RX.baud_cnt\[26\] _1225_ _1227_ VGND VGND VPWR VPWR _0158_ sky130_fd_sc_hd__o21a_1
XFILLER_0_23_111 VGND VGND VPWR VPWR sky130_fd_sc_hd__fill_1
X_2381_ _0509_ _0567_ _0569_ VGND VGND VPWR VPWR _0570_ sky130_fd_sc_hd__a21oi_1
X_2450_ _0629_ _0635_ _0638_ VGND VGND VPWR VPWR _0639_ sky130_fd_sc_hd__and3_2
Xinput5 S_AXI_ARADDR[13] VGND VGND VPWR VPWR net5 sky130_fd_sc_hd__buf_1
XFILLER_0_39_9 VGND VGND VPWR VPWR sky130_fd_sc_hd__fill_1
X_3002_ _1163_ _1158_ _1172_ _1154_ RX.baud_cnt\[4\] VGND VGND VPWR VPWR _0136_ sky130_fd_sc_hd__a32o_1
XFILLER_0_52_85 VGND VGND VPWR VPWR sky130_fd_sc_hd__fill_1
X_2717_ _0894_ VGND VGND VPWR VPWR _0129_ sky130_fd_sc_hd__clkbuf_1
XFILLER_0_46_269 VGND VGND VPWR VPWR sky130_fd_sc_hd__fill_1
X_3697_ clknet_leaf_19_S_AXI_ACLK _0262_ net150 VGND VGND VPWR VPWR TX.baud_counter\[28\]
+ sky130_fd_sc_hd__dfrtp_4
X_2648_ TX.baud_counter\[10\] _0836_ VGND VGND VPWR VPWR _0837_ sky130_fd_sc_hd__or2_1
X_2579_ TX.baud_counter\[30\] _0767_ _0766_ TX.baud_counter\[31\] VGND VGND VPWR VPWR
+ _0768_ sky130_fd_sc_hd__a22o_1
XFILLER_0_37_203 VGND VGND VPWR VPWR sky130_fd_sc_hd__fill_1
X_1950_ _1651_ VGND VGND VPWR VPWR _0040_ sky130_fd_sc_hd__clkbuf_1
X_3620_ clknet_leaf_7_S_AXI_ACLK _0185_ net159 VGND VGND VPWR VPWR RX.rx_shifter\[18\]
+ sky130_fd_sc_hd__dfrtp_1
X_1881_ TX.uart_tdr\[18\] _1566_ _1567_ RX.uart_stp\[18\] VGND VGND VPWR VPWR _1597_
+ sky130_fd_sc_hd__a22o_1
X_3551_ clknet_leaf_8_S_AXI_ACLK _0116_ VGND VGND VPWR VPWR TX.uart_tdr\[14\] sky130_fd_sc_hd__dfxtp_1
X_2502_ _0569_ _0509_ _0567_ VGND VGND VPWR VPWR _0691_ sky130_fd_sc_hd__and3_1
X_2364_ _1596_ RX.uart_cpb\[17\] VGND VGND VPWR VPWR _0553_ sky130_fd_sc_hd__xnor2_1
X_3482_ clknet_leaf_10_S_AXI_ACLK _0047_ VGND VGND VPWR VPWR uart_rdr\[7\] sky130_fd_sc_hd__dfxtp_1
X_2433_ _0312_ _1522_ _0581_ _0293_ VGND VGND VPWR VPWR _0622_ sky130_fd_sc_hd__a2bb2o_1
X_2295_ net297 _0484_ VGND VGND VPWR VPWR _0493_ sky130_fd_sc_hd__or2_1
XFILLER_0_47_85 VGND VGND VPWR VPWR sky130_fd_sc_hd__fill_1
XFILLER_0_2_10 VPWR VGND VPWR VGND sky130_ef_sc_hd__decap_12
XPHY_109 VGND VGND VPWR VPWR sky130_fd_sc_hd__decap_3
XFILLER_0_34_206 VGND VGND VPWR VPWR sky130_fd_sc_hd__fill_1
XANTENNA_10 S_AXI_AWADDR[16] VGND VGND VPWR VPWR sky130_fd_sc_hd__diode_2
XFILLER_0_19_225 VGND VGND VPWR VPWR sky130_fd_sc_hd__decap_3
XFILLER_0_57_309 VGND VGND VPWR VPWR sky130_fd_sc_hd__fill_2
X_2080_ _0306_ VGND VGND VPWR VPWR _0307_ sky130_fd_sc_hd__clkbuf_4
X_1933_ RX.uart_cpb\[29\] _1521_ _1636_ _1637_ VGND VGND VPWR VPWR _1638_ sky130_fd_sc_hd__a211o_1
X_2982_ _1057_ _1156_ VGND VGND VPWR VPWR _1157_ sky130_fd_sc_hd__and2_1
Xinput85 S_AXI_WDATA[23] VGND VGND VPWR VPWR net85 sky130_fd_sc_hd__buf_1
X_3465_ clknet_leaf_1_S_AXI_ACLK _0030_ VGND VGND VPWR VPWR net125 sky130_fd_sc_hd__dfxtp_1
Xinput52 S_AXI_AWADDR[25] VGND VGND VPWR VPWR net52 sky130_fd_sc_hd__clkbuf_1
X_1864_ uart_rdr\[14\] _1580_ _1550_ VGND VGND VPWR VPWR _1584_ sky130_fd_sc_hd__a21bo_1
Xinput74 S_AXI_WDATA[13] VGND VGND VPWR VPWR net74 sky130_fd_sc_hd__clkbuf_2
Xinput30 S_AXI_ARADDR[7] VGND VGND VPWR VPWR net30 sky130_fd_sc_hd__clkbuf_2
X_3603_ clknet_leaf_9_S_AXI_ACLK _0168_ net160 VGND VGND VPWR VPWR RX.rx_shifter\[1\]
+ sky130_fd_sc_hd__dfrtp_1
X_1795_ TX.data_latch_next\[1\] _1507_ _1509_ _1526_ _1527_ VGND VGND VPWR VPWR _1528_
+ sky130_fd_sc_hd__a221o_1
Xinput41 S_AXI_AWADDR[15] VGND VGND VPWR VPWR net41 sky130_fd_sc_hd__buf_1
XFILLER_0_3_166 VGND VGND VPWR VPWR sky130_fd_sc_hd__fill_2
XFILLER_0_3_111 VGND VGND VPWR VPWR sky130_fd_sc_hd__fill_1
Xinput96 S_AXI_WDATA[4] VGND VGND VPWR VPWR net96 sky130_fd_sc_hd__clkbuf_2
Xinput63 S_AXI_AWADDR[6] VGND VGND VPWR VPWR net63 sky130_fd_sc_hd__clkbuf_2
X_3534_ clknet_leaf_21_S_AXI_ACLK _0099_ VGND VGND VPWR VPWR net109 sky130_fd_sc_hd__dfxtp_4
X_2278_ _0482_ VGND VGND VPWR VPWR _0483_ sky130_fd_sc_hd__buf_2
XFILLER_0_35_3 VGND VGND VPWR VPWR sky130_fd_sc_hd__fill_2
X_2347_ RX.uart_cpb\[10\] RX.uart_cpb\[8\] _1562_ VGND VGND VPWR VPWR _0536_ sky130_fd_sc_hd__o21ai_1
X_3396_ _1364_ _1436_ _1438_ _1403_ net256 VGND VGND VPWR VPWR _0264_ sky130_fd_sc_hd__a32o_1
X_2416_ RX.uart_cpb\[8\] _0312_ _0604_ _1562_ VGND VGND VPWR VPWR _0605_ sky130_fd_sc_hd__o22a_1
XTAP_459 VGND VPWR sky130_fd_sc_hd__tapvpwrvgnd_1
XTAP_448 VGND VPWR sky130_fd_sc_hd__tapvpwrvgnd_1
XTAP_437 VGND VPWR sky130_fd_sc_hd__tapvpwrvgnd_1
X_3250_ net320 _1329_ VGND VGND VPWR VPWR _1332_ sky130_fd_sc_hd__or2_1
XTAP_426 VGND VPWR sky130_fd_sc_hd__tapvpwrvgnd_1
X_3181_ _1289_ VGND VGND VPWR VPWR _0198_ sky130_fd_sc_hd__clkbuf_1
XTAP_415 VGND VPWR sky130_fd_sc_hd__tapvpwrvgnd_1
XTAP_404 VGND VPWR sky130_fd_sc_hd__tapvpwrvgnd_1
X_2201_ _0341_ _0342_ VGND VGND VPWR VPWR _0412_ sky130_fd_sc_hd__nor2_1
X_2132_ RX.uart_cpb\[19\] _1596_ VGND VGND VPWR VPWR _0343_ sky130_fd_sc_hd__or2_1
XFILLER_0_0_169 VGND VGND VPWR VPWR sky130_fd_sc_hd__fill_1
XFILLER_0_48_139 VGND VGND VPWR VPWR sky130_fd_sc_hd__fill_1
X_2063_ net81 _0290_ _0294_ _0296_ VGND VGND VPWR VPWR _0073_ sky130_fd_sc_hd__o211a_1
X_1916_ _1609_ net204 _1600_ _1624_ VGND VGND VPWR VPWR _0033_ sky130_fd_sc_hd__o211a_1
X_1847_ _1534_ net251 _1561_ _1570_ VGND VGND VPWR VPWR _0018_ sky130_fd_sc_hd__o211a_1
X_2965_ _1119_ _1123_ _1141_ VGND VGND VPWR VPWR _1142_ sky130_fd_sc_hd__or3_1
X_2896_ RX.baud_cnt\[6\] _0826_ _0829_ RX.baud_cnt\[7\] VGND VGND VPWR VPWR _1073_
+ sky130_fd_sc_hd__a22o_1
X_1778_ net26 net331 _1511_ VGND VGND VPWR VPWR _1512_ sky130_fd_sc_hd__and3_2
X_3448_ clknet_leaf_14_S_AXI_ACLK _0013_ VGND VGND VPWR VPWR net138 sky130_fd_sc_hd__dfxtp_1
XFILLER_0_12_253 VGND VGND VPWR VPWR sky130_fd_sc_hd__fill_1
X_3517_ clknet_leaf_14_S_AXI_ACLK _0082_ VGND VGND VPWR VPWR RX.uart_stp\[2\] sky130_fd_sc_hd__dfxtp_1
X_3379_ TX.baud_counter\[26\] TX.baud_counter\[25\] _1421_ VGND VGND VPWR VPWR _1426_
+ sky130_fd_sc_hd__and3_1
XFILLER_0_14_12 VGND VGND VPWR VPWR sky130_fd_sc_hd__fill_1
X_2750_ RX.baud_cnt\[4\] _0359_ _0362_ _0922_ VGND VGND VPWR VPWR _0927_ sky130_fd_sc_hd__a22o_1
X_2681_ TX.baud_counter\[30\] _0767_ VGND VGND VPWR VPWR _0870_ sky130_fd_sc_hd__or2_1
XFILLER_0_30_88 VGND VGND VPWR VPWR sky130_fd_sc_hd__decap_6
X_3302_ _1348_ VGND VGND VPWR VPWR _1369_ sky130_fd_sc_hd__buf_2
XTAP_201 VGND VPWR sky130_fd_sc_hd__tapvpwrvgnd_1
XTAP_212 VGND VPWR sky130_fd_sc_hd__tapvpwrvgnd_1
XTAP_223 VGND VPWR sky130_fd_sc_hd__tapvpwrvgnd_1
X_3164_ net227 VGND VGND VPWR VPWR _1281_ sky130_fd_sc_hd__clkbuf_1
X_3233_ _0295_ VGND VGND VPWR VPWR _1322_ sky130_fd_sc_hd__clkbuf_4
X_3095_ RX.state\[0\] _1150_ VGND VGND VPWR VPWR _1238_ sky130_fd_sc_hd__or2_1
XTAP_289 VGND VPWR sky130_fd_sc_hd__tapvpwrvgnd_1
XTAP_278 VGND VPWR sky130_fd_sc_hd__tapvpwrvgnd_1
XTAP_267 VGND VPWR sky130_fd_sc_hd__tapvpwrvgnd_1
X_2115_ net96 _0323_ _0329_ _0321_ VGND VGND VPWR VPWR _0092_ sky130_fd_sc_hd__o211a_1
XTAP_234 VGND VPWR sky130_fd_sc_hd__tapvpwrvgnd_1
XTAP_245 VGND VPWR sky130_fd_sc_hd__tapvpwrvgnd_1
XTAP_256 VGND VPWR sky130_fd_sc_hd__tapvpwrvgnd_1
X_2046_ _1700_ _0282_ VGND VGND VPWR VPWR _0283_ sky130_fd_sc_hd__and2_1
XFILLER_0_44_197 VGND VGND VPWR VPWR sky130_fd_sc_hd__fill_2
X_2879_ _0994_ _1013_ _1043_ _1055_ VGND VGND VPWR VPWR _1056_ sky130_fd_sc_hd__or4_1
X_2948_ _0959_ _0866_ _1120_ _1124_ _1118_ VGND VGND VPWR VPWR _1125_ sky130_fd_sc_hd__o221a_1
XFILLER_0_25_99 VGND VGND VPWR VPWR sky130_fd_sc_hd__fill_2
X_2802_ _0977_ VGND VGND VPWR VPWR _0979_ sky130_fd_sc_hd__inv_2
XFILLER_0_26_197 VGND VGND VPWR VPWR sky130_fd_sc_hd__fill_2
X_2733_ RX.baud_cnt\[13\] VGND VGND VPWR VPWR _0910_ sky130_fd_sc_hd__buf_2
X_2664_ TX.baud_counter\[17\] _0798_ _0852_ TX.baud_counter\[16\] VGND VGND VPWR VPWR
+ _0853_ sky130_fd_sc_hd__a22o_1
XFILLER_0_5_21 VGND VGND VPWR VPWR sky130_fd_sc_hd__decap_8
X_2595_ TX.baud_counter\[21\] _0781_ _0783_ TX.baud_counter\[20\] VGND VGND VPWR VPWR
+ _0784_ sky130_fd_sc_hd__a22o_1
X_3147_ _1272_ VGND VGND VPWR VPWR _0181_ sky130_fd_sc_hd__clkbuf_1
X_3216_ _0350_ _1304_ VGND VGND VPWR VPWR _1311_ sky130_fd_sc_hd__nand2_1
X_3078_ _1176_ _1226_ _1152_ VGND VGND VPWR VPWR _1227_ sky130_fd_sc_hd__o21bai_1
X_2029_ _1706_ VGND VGND VPWR VPWR _0064_ sky130_fd_sc_hd__clkbuf_1
XFILLER_0_49_289 VGND VGND VPWR VPWR sky130_fd_sc_hd__fill_2
XFILLER_0_9_353 VGND VGND VPWR VPWR sky130_fd_sc_hd__fill_2
XFILLER_0_17_142 VGND VGND VPWR VPWR sky130_fd_sc_hd__decap_3
XFILLER_0_20_307 VGND VGND VPWR VPWR sky130_fd_sc_hd__fill_1
X_2380_ _0507_ _0568_ VGND VGND VPWR VPWR _0569_ sky130_fd_sc_hd__nand2_1
XFILLER_0_36_65 VGND VGND VPWR VPWR sky130_fd_sc_hd__fill_2
XFILLER_0_36_21 VGND VGND VPWR VPWR sky130_fd_sc_hd__fill_2
Xinput6 S_AXI_ARADDR[14] VGND VGND VPWR VPWR net6 sky130_fd_sc_hd__dlymetal6s2s_1
X_3001_ _1170_ _1171_ VGND VGND VPWR VPWR _1172_ sky130_fd_sc_hd__nor2_1
XFILLER_0_52_75 VGND VGND VPWR VPWR sky130_fd_sc_hd__fill_2
X_2716_ _1495_ _1485_ net34 VGND VGND VPWR VPWR _0894_ sky130_fd_sc_hd__and3b_1
X_3696_ clknet_leaf_20_S_AXI_ACLK _0261_ net153 VGND VGND VPWR VPWR TX.baud_counter\[27\]
+ sky130_fd_sc_hd__dfrtp_4
XFILLER_0_14_156 VGND VGND VPWR VPWR sky130_fd_sc_hd__fill_1
X_2647_ _0648_ _0654_ VGND VGND VPWR VPWR _0836_ sky130_fd_sc_hd__xor2_2
X_2578_ _0755_ _0761_ VGND VGND VPWR VPWR _0767_ sky130_fd_sc_hd__xor2_2
XFILLER_0_10_362 VGND VGND VPWR VPWR sky130_fd_sc_hd__fill_2
XPHY_90 VGND VGND VPWR VPWR sky130_fd_sc_hd__decap_3
X_1880_ RX.uart_cpb\[18\] VGND VGND VPWR VPWR _1596_ sky130_fd_sc_hd__buf_4
X_3550_ clknet_leaf_7_S_AXI_ACLK _0115_ VGND VGND VPWR VPWR TX.uart_tdr\[13\] sky130_fd_sc_hd__dfxtp_1
X_3481_ clknet_leaf_10_S_AXI_ACLK _0046_ VGND VGND VPWR VPWR uart_rdr\[6\] sky130_fd_sc_hd__dfxtp_1
X_2501_ _0689_ VGND VGND VPWR VPWR _0690_ sky130_fd_sc_hd__clkbuf_4
XFILLER_0_3_337 VGND VGND VPWR VPWR sky130_fd_sc_hd__decap_8
XFILLER_0_11_126 VGND VGND VPWR VPWR sky130_fd_sc_hd__fill_2
X_2294_ net84 _0483_ _0492_ _0487_ VGND VGND VPWR VPWR _0108_ sky130_fd_sc_hd__o211a_1
XFILLER_0_47_42 VGND VGND VPWR VPWR sky130_fd_sc_hd__fill_1
X_2363_ _0342_ _0551_ VGND VGND VPWR VPWR _0552_ sky130_fd_sc_hd__nand2_1
X_2432_ _0293_ _0618_ _0619_ _0620_ RX.uart_stp\[0\] VGND VGND VPWR VPWR _0621_ sky130_fd_sc_hd__o221a_1
XFILLER_0_2_22 VGND VGND VPWR VPWR sky130_fd_sc_hd__decap_6
XANTENNA_11 net16 VGND VGND VPWR VPWR sky130_fd_sc_hd__diode_2
XFILLER_0_42_251 VGND VGND VPWR VPWR sky130_fd_sc_hd__fill_1
X_3679_ clknet_leaf_19_S_AXI_ACLK _0244_ net150 VGND VGND VPWR VPWR TX.baud_counter\[10\]
+ sky130_fd_sc_hd__dfrtp_4
Xoutput140 net140 VGND VGND VPWR VPWR S_AXI_RDATA[7] sky130_fd_sc_hd__clkbuf_4
XFILLER_0_6_197 VGND VGND VPWR VPWR sky130_fd_sc_hd__fill_2
XFILLER_0_0_307 VGND VGND VPWR VPWR sky130_fd_sc_hd__fill_1
XFILLER_0_0_329 VGND VGND VPWR VPWR sky130_fd_sc_hd__fill_2
XFILLER_0_17_12 VGND VGND VPWR VPWR sky130_fd_sc_hd__fill_1
Xinput20 S_AXI_ARADDR[27] VGND VGND VPWR VPWR net20 sky130_fd_sc_hd__buf_1
X_1863_ TX.uart_tdr\[14\] _1566_ _1567_ RX.uart_stp\[14\] VGND VGND VPWR VPWR _1583_
+ sky130_fd_sc_hd__a22o_1
X_1932_ uart_rdr\[29\] _1513_ _1494_ VGND VGND VPWR VPWR _1637_ sky130_fd_sc_hd__a21bo_1
X_3602_ clknet_leaf_11_S_AXI_ACLK _0167_ net160 VGND VGND VPWR VPWR RX.rx_shifter\[0\]
+ sky130_fd_sc_hd__dfrtp_1
X_2981_ RX.state\[1\] _1155_ VGND VGND VPWR VPWR _1156_ sky130_fd_sc_hd__nand2_1
XFILLER_0_33_77 VGND VGND VPWR VPWR sky130_fd_sc_hd__decap_8
Xinput31 S_AXI_ARADDR[8] VGND VGND VPWR VPWR net31 sky130_fd_sc_hd__dlymetal6s2s_1
Xinput53 S_AXI_AWADDR[26] VGND VGND VPWR VPWR net53 sky130_fd_sc_hd__clkbuf_1
Xinput86 S_AXI_WDATA[24] VGND VGND VPWR VPWR net86 sky130_fd_sc_hd__dlymetal6s2s_1
Xinput64 S_AXI_AWADDR[7] VGND VGND VPWR VPWR net64 sky130_fd_sc_hd__clkbuf_1
X_3464_ clknet_leaf_1_S_AXI_ACLK _0029_ VGND VGND VPWR VPWR net124 sky130_fd_sc_hd__dfxtp_1
X_1794_ uart_rdr\[1\] _1512_ _1494_ VGND VGND VPWR VPWR _1527_ sky130_fd_sc_hd__a21bo_1
Xinput75 S_AXI_WDATA[14] VGND VGND VPWR VPWR net75 sky130_fd_sc_hd__clkbuf_2
X_3533_ clknet_leaf_13_S_AXI_ACLK _0098_ net157 VGND VGND VPWR VPWR TX.bit_index\[2\]
+ sky130_fd_sc_hd__dfrtp_1
Xinput97 S_AXI_WDATA[5] VGND VGND VPWR VPWR net97 sky130_fd_sc_hd__clkbuf_2
X_2415_ _0603_ VGND VGND VPWR VPWR _0604_ sky130_fd_sc_hd__clkbuf_4
Xinput42 S_AXI_AWADDR[16] VGND VGND VPWR VPWR net42 sky130_fd_sc_hd__buf_1
X_2277_ _1479_ _0481_ VGND VGND VPWR VPWR _0482_ sky130_fd_sc_hd__or2_1
X_2346_ RX.uart_cpb\[11\] VGND VGND VPWR VPWR _0535_ sky130_fd_sc_hd__inv_2
XFILLER_0_28_3 VGND VGND VPWR VPWR sky130_fd_sc_hd__fill_1
X_3395_ _1381_ _1437_ VGND VGND VPWR VPWR _1438_ sky130_fd_sc_hd__nor2_1
Xclkbuf_leaf_17_S_AXI_ACLK clknet_1_0__leaf_S_AXI_ACLK VGND VGND VPWR VPWR clknet_leaf_17_S_AXI_ACLK
+ sky130_fd_sc_hd__clkbuf_16
XFILLER_0_53_357 VGND VGND VPWR VPWR sky130_fd_sc_hd__fill_1
XTAP_405 VGND VPWR sky130_fd_sc_hd__tapvpwrvgnd_1
XTAP_449 VGND VPWR sky130_fd_sc_hd__tapvpwrvgnd_1
XTAP_438 VGND VPWR sky130_fd_sc_hd__tapvpwrvgnd_1
X_3180_ net212 VGND VGND VPWR VPWR _1289_ sky130_fd_sc_hd__clkbuf_1
XTAP_427 VGND VPWR sky130_fd_sc_hd__tapvpwrvgnd_1
XTAP_416 VGND VPWR sky130_fd_sc_hd__tapvpwrvgnd_1
X_2062_ _0295_ VGND VGND VPWR VPWR _0296_ sky130_fd_sc_hd__clkbuf_4
X_2131_ RX.uart_cpb\[17\] RX.uart_cpb\[16\] VGND VGND VPWR VPWR _0342_ sky130_fd_sc_hd__or2_1
X_2200_ _0402_ _0407_ _0409_ TX.baud_counter\[16\] _0410_ VGND VGND VPWR VPWR _0411_
+ sky130_fd_sc_hd__o221a_1
XFILLER_0_8_226 VGND VGND VPWR VPWR sky130_fd_sc_hd__fill_1
X_2964_ _1073_ _1090_ _1111_ _1140_ VGND VGND VPWR VPWR _1141_ sky130_fd_sc_hd__or4_1
X_1777_ _1510_ VGND VGND VPWR VPWR _1511_ sky130_fd_sc_hd__inv_2
X_1915_ RX.uart_cpb\[25\] _1521_ _1622_ _1623_ VGND VGND VPWR VPWR _1624_ sky130_fd_sc_hd__a211o_1
X_1846_ RX.uart_cpb\[10\] _1536_ _1568_ _1569_ VGND VGND VPWR VPWR _1570_ sky130_fd_sc_hd__a211o_1
X_2895_ _1059_ _1070_ _1071_ VGND VGND VPWR VPWR _1072_ sky130_fd_sc_hd__a21oi_1
X_3516_ clknet_leaf_11_S_AXI_ACLK _0081_ VGND VGND VPWR VPWR RX.uart_stp\[1\] sky130_fd_sc_hd__dfxtp_1
X_3447_ clknet_leaf_14_S_AXI_ACLK _0012_ VGND VGND VPWR VPWR net137 sky130_fd_sc_hd__dfxtp_1
X_3378_ TX.baud_counter\[25\] _1421_ TX.baud_counter\[26\] VGND VGND VPWR VPWR _1425_
+ sky130_fd_sc_hd__a21oi_1
X_2329_ _0335_ _0516_ _0517_ VGND VGND VPWR VPWR _0518_ sky130_fd_sc_hd__and3_1
XFILLER_0_47_151 VGND VGND VPWR VPWR sky130_fd_sc_hd__fill_2
XFILLER_0_53_110 VGND VGND VPWR VPWR sky130_fd_sc_hd__fill_2
XFILLER_0_38_195 VGND VGND VPWR VPWR sky130_fd_sc_hd__fill_1
X_2680_ _0863_ _0864_ _0867_ _0868_ VGND VGND VPWR VPWR _0869_ sky130_fd_sc_hd__o31a_1
XFILLER_0_39_98 VGND VGND VPWR VPWR sky130_fd_sc_hd__fill_2
X_3232_ _0535_ _1318_ VGND VGND VPWR VPWR _1321_ sky130_fd_sc_hd__nand2_1
X_3301_ _1342_ _1364_ _1367_ _1368_ net240 VGND VGND VPWR VPWR _0239_ sky130_fd_sc_hd__a32o_1
XTAP_202 VGND VPWR sky130_fd_sc_hd__tapvpwrvgnd_1
XTAP_213 VGND VPWR sky130_fd_sc_hd__tapvpwrvgnd_1
XTAP_224 VGND VPWR sky130_fd_sc_hd__tapvpwrvgnd_1
XTAP_235 VGND VPWR sky130_fd_sc_hd__tapvpwrvgnd_1
XTAP_246 VGND VPWR sky130_fd_sc_hd__tapvpwrvgnd_1
XTAP_257 VGND VPWR sky130_fd_sc_hd__tapvpwrvgnd_1
X_3163_ _1280_ VGND VGND VPWR VPWR _0189_ sky130_fd_sc_hd__clkbuf_1
XFILLER_0_55_31 VPWR VGND VPWR VGND sky130_ef_sc_hd__decap_12
X_2045_ RX.done_reg RX.rx_shifter\[30\] _1648_ uart_rdr\[30\] VGND VGND VPWR VPWR
+ _0282_ sky130_fd_sc_hd__a22o_1
X_3094_ RX.baud_cnt\[31\] _1237_ _1156_ VGND VGND VPWR VPWR _0163_ sky130_fd_sc_hd__o21ba_1
XTAP_279 VGND VPWR sky130_fd_sc_hd__tapvpwrvgnd_1
XTAP_268 VGND VPWR sky130_fd_sc_hd__tapvpwrvgnd_1
X_2114_ TX.data_latch_next\[4\] _0324_ VGND VGND VPWR VPWR _0329_ sky130_fd_sc_hd__or2_1
XFILLER_0_44_121 VGND VGND VPWR VPWR sky130_fd_sc_hd__fill_1
X_2947_ RX.baud_cnt\[25\] _0775_ _0773_ RX.baud_cnt\[24\] VGND VGND VPWR VPWR _1124_
+ sky130_fd_sc_hd__o22a_1
XFILLER_0_4_251 VGND VGND VPWR VPWR sky130_fd_sc_hd__fill_1
X_2878_ _1015_ _1017_ _1053_ _1054_ VGND VGND VPWR VPWR _1055_ sky130_fd_sc_hd__or4_1
X_1829_ _1553_ _1536_ _1554_ _1555_ VGND VGND VPWR VPWR _1556_ sky130_fd_sc_hd__a211o_1
XFILLER_0_35_176 VGND VGND VPWR VPWR sky130_fd_sc_hd__decap_3
XFILLER_0_35_110 VGND VGND VPWR VPWR sky130_fd_sc_hd__fill_2
XFILLER_0_23_327 VGND VGND VPWR VPWR sky130_fd_sc_hd__fill_1
Xclkbuf_leaf_7_S_AXI_ACLK clknet_1_1__leaf_S_AXI_ACLK VGND VGND VPWR VPWR clknet_leaf_7_S_AXI_ACLK
+ sky130_fd_sc_hd__clkbuf_16
XFILLER_0_25_45 VGND VGND VPWR VPWR sky130_fd_sc_hd__decap_8
X_2801_ _0455_ RX.baud_cnt\[27\] VGND VGND VPWR VPWR _0978_ sky130_fd_sc_hd__and2_1
XFILLER_0_41_113 VGND VGND VPWR VPWR sky130_fd_sc_hd__fill_1
XFILLER_0_41_77 VGND VGND VPWR VPWR sky130_fd_sc_hd__fill_2
X_2663_ _0676_ _0680_ VGND VGND VPWR VPWR _0852_ sky130_fd_sc_hd__xnor2_2
X_2594_ _0690_ _0701_ VGND VGND VPWR VPWR _0783_ sky130_fd_sc_hd__xor2_2
X_2732_ _0897_ _0347_ _0899_ _0908_ VGND VGND VPWR VPWR _0909_ sky130_fd_sc_hd__o22ai_1
X_3215_ net82 _1305_ _1310_ _1302_ VGND VGND VPWR VPWR _0211_ sky130_fd_sc_hd__o211a_1
X_2028_ _1700_ _1705_ VGND VGND VPWR VPWR _1706_ sky130_fd_sc_hd__and2_1
X_3146_ net239 VGND VGND VPWR VPWR _1272_ sky130_fd_sc_hd__clkbuf_1
X_3077_ RX.baud_cnt\[26\] RX.baud_cnt\[25\] _1221_ VGND VGND VPWR VPWR _1226_ sky130_fd_sc_hd__and3_1
X_3000_ RX.baud_cnt\[4\] RX.baud_cnt\[3\] _1166_ VGND VGND VPWR VPWR _1171_ sky130_fd_sc_hd__and3_1
Xinput7 S_AXI_ARADDR[15] VGND VGND VPWR VPWR net7 sky130_fd_sc_hd__buf_1
X_2715_ net85 _0883_ _0893_ _0890_ VGND VGND VPWR VPWR _0128_ sky130_fd_sc_hd__o211a_1
X_2577_ _0762_ _0765_ VGND VGND VPWR VPWR _0766_ sky130_fd_sc_hd__xnor2_4
X_3695_ clknet_leaf_21_S_AXI_ACLK _0260_ net148 VGND VGND VPWR VPWR TX.baud_counter\[26\]
+ sky130_fd_sc_hd__dfrtp_4
XFILLER_0_14_124 VGND VGND VPWR VPWR sky130_fd_sc_hd__fill_1
X_2646_ TX.baud_counter\[9\] _0807_ _0832_ TX.baud_counter\[8\] VGND VGND VPWR VPWR
+ _0835_ sky130_fd_sc_hd__a22o_1
X_3129_ _0970_ _1258_ RX.bit_idx\[1\] VGND VGND VPWR VPWR _1263_ sky130_fd_sc_hd__or3b_1
XPHY_91 VGND VGND VPWR VPWR sky130_fd_sc_hd__decap_3
XPHY_80 VGND VGND VPWR VPWR sky130_fd_sc_hd__decap_3
XFILLER_0_28_205 VGND VGND VPWR VPWR sky130_fd_sc_hd__fill_2
XFILLER_0_22_79 VGND VGND VPWR VPWR sky130_fd_sc_hd__decap_4
XFILLER_0_51_230 VGND VGND VPWR VPWR sky130_fd_sc_hd__fill_2
X_3480_ clknet_leaf_10_S_AXI_ACLK _0045_ VGND VGND VPWR VPWR uart_rdr\[5\] sky130_fd_sc_hd__dfxtp_1
X_2500_ _0592_ _0676_ _0688_ VGND VGND VPWR VPWR _0689_ sky130_fd_sc_hd__and3_1
X_2431_ RX.uart_stp\[1\] _1532_ VGND VGND VPWR VPWR _0620_ sky130_fd_sc_hd__nor2_1
X_2293_ net247 _0484_ VGND VGND VPWR VPWR _0492_ sky130_fd_sc_hd__or2_1
XFILLER_0_47_65 VGND VGND VPWR VPWR sky130_fd_sc_hd__decap_4
X_2362_ RX.uart_cpb\[17\] RX.uart_cpb\[16\] VGND VGND VPWR VPWR _0551_ sky130_fd_sc_hd__nand2_1
XFILLER_0_2_45 VGND VGND VPWR VPWR sky130_fd_sc_hd__fill_1
XANTENNA_12 net24 VGND VGND VPWR VPWR sky130_fd_sc_hd__diode_2
Xoutput141 net141 VGND VGND VPWR VPWR S_AXI_RDATA[8] sky130_fd_sc_hd__buf_2
Xoutput130 net130 VGND VGND VPWR VPWR S_AXI_RDATA[27] sky130_fd_sc_hd__clkbuf_4
X_2629_ _0811_ _0815_ _0816_ _0817_ VGND VGND VPWR VPWR _0818_ sky130_fd_sc_hd__o31ai_1
X_3678_ clknet_leaf_19_S_AXI_ACLK _0243_ net150 VGND VGND VPWR VPWR TX.baud_counter\[9\]
+ sky130_fd_sc_hd__dfrtp_4
X_2980_ RX.state\[0\] _0969_ VGND VGND VPWR VPWR _1155_ sky130_fd_sc_hd__or2b_1
XFILLER_0_33_23 VGND VGND VPWR VPWR sky130_fd_sc_hd__fill_2
Xinput43 S_AXI_AWADDR[17] VGND VGND VPWR VPWR net43 sky130_fd_sc_hd__clkbuf_1
Xinput32 S_AXI_ARADDR[9] VGND VGND VPWR VPWR net32 sky130_fd_sc_hd__buf_1
X_1862_ _1571_ net190 _1561_ _1582_ VGND VGND VPWR VPWR _0021_ sky130_fd_sc_hd__o211a_1
X_1931_ TX.uart_tdr\[29\] _1604_ _1605_ RX.uart_stp\[29\] VGND VGND VPWR VPWR _1636_
+ sky130_fd_sc_hd__a22o_1
Xinput10 S_AXI_ARADDR[18] VGND VGND VPWR VPWR net10 sky130_fd_sc_hd__clkbuf_2
X_3601_ clknet_leaf_11_S_AXI_ACLK _0166_ net159 VGND VGND VPWR VPWR RX.bit_idx\[2\]
+ sky130_fd_sc_hd__dfrtp_2
X_1793_ _1525_ VGND VGND VPWR VPWR _1526_ sky130_fd_sc_hd__clkbuf_4
Xinput54 S_AXI_AWADDR[27] VGND VGND VPWR VPWR net54 sky130_fd_sc_hd__buf_1
Xinput21 S_AXI_ARADDR[28] VGND VGND VPWR VPWR net21 sky130_fd_sc_hd__buf_1
Xinput65 S_AXI_AWADDR[8] VGND VGND VPWR VPWR net65 sky130_fd_sc_hd__dlymetal6s2s_1
Xinput76 S_AXI_WDATA[15] VGND VGND VPWR VPWR net76 sky130_fd_sc_hd__clkbuf_2
Xinput87 S_AXI_WDATA[25] VGND VGND VPWR VPWR net87 sky130_fd_sc_hd__buf_1
X_3463_ clknet_leaf_0_S_AXI_ACLK _0028_ VGND VGND VPWR VPWR net123 sky130_fd_sc_hd__dfxtp_2
Xinput98 S_AXI_WDATA[6] VGND VGND VPWR VPWR net98 sky130_fd_sc_hd__clkbuf_2
X_3394_ TX.baud_counter\[30\] _1434_ VGND VGND VPWR VPWR _1437_ sky130_fd_sc_hd__and2_1
X_2414_ _1525_ RX.uart_stp\[0\] VGND VGND VPWR VPWR _0603_ sky130_fd_sc_hd__or2_1
X_3532_ clknet_leaf_13_S_AXI_ACLK _0097_ net157 VGND VGND VPWR VPWR TX.bit_index\[1\]
+ sky130_fd_sc_hd__dfrtp_1
X_2276_ net109 net104 VGND VGND VPWR VPWR _0481_ sky130_fd_sc_hd__nand2_2
X_2345_ _0513_ _0515_ _0530_ _0533_ VGND VGND VPWR VPWR _0534_ sky130_fd_sc_hd__or4_2
XFILLER_0_57_108 VGND VGND VPWR VPWR sky130_fd_sc_hd__fill_1
XTAP_439 VGND VPWR sky130_fd_sc_hd__tapvpwrvgnd_1
XTAP_428 VGND VPWR sky130_fd_sc_hd__tapvpwrvgnd_1
XTAP_417 VGND VPWR sky130_fd_sc_hd__tapvpwrvgnd_1
XTAP_406 VGND VPWR sky130_fd_sc_hd__tapvpwrvgnd_1
XFILLER_0_21_222 VGND VGND VPWR VPWR sky130_fd_sc_hd__fill_2
X_2061_ net159 VGND VGND VPWR VPWR _0295_ sky130_fd_sc_hd__buf_2
X_2130_ _0340_ VGND VGND VPWR VPWR _0341_ sky130_fd_sc_hd__buf_2
X_1914_ uart_rdr\[25\] _1513_ _1590_ VGND VGND VPWR VPWR _1623_ sky130_fd_sc_hd__a21bo_1
XFILLER_0_44_66 VGND VGND VPWR VPWR sky130_fd_sc_hd__fill_1
X_2963_ _1071_ _1139_ _1069_ _1074_ VGND VGND VPWR VPWR _1140_ sky130_fd_sc_hd__or4b_1
X_1845_ uart_rdr\[10\] _1538_ _1550_ VGND VGND VPWR VPWR _1569_ sky130_fd_sc_hd__a21bo_1
X_1776_ net12 net1 net23 _1503_ VGND VGND VPWR VPWR _1510_ sky130_fd_sc_hd__or4b_1
X_3515_ clknet_leaf_11_S_AXI_ACLK _0080_ VGND VGND VPWR VPWR RX.uart_stp\[0\] sky130_fd_sc_hd__dfxtp_2
X_2894_ RX.baud_cnt\[6\] _0826_ VGND VGND VPWR VPWR _1071_ sky130_fd_sc_hd__nor2_1
X_3446_ clknet_leaf_9_S_AXI_ACLK _0011_ VGND VGND VPWR VPWR net136 sky130_fd_sc_hd__dfxtp_1
X_3377_ TX.baud_counter\[25\] _1355_ _1350_ _1424_ VGND VGND VPWR VPWR _0259_ sky130_fd_sc_hd__a22o_1
X_2328_ RX.uart_cpb\[8\] _1553_ VGND VGND VPWR VPWR _0517_ sky130_fd_sc_hd__xor2_2
X_2259_ TX.bit_index\[0\] TX.bit_index\[1\] VGND VGND VPWR VPWR _0470_ sky130_fd_sc_hd__and2_1
XFILLER_0_47_185 VGND VGND VPWR VPWR sky130_fd_sc_hd__fill_2
XFILLER_0_7_271 VGND VGND VPWR VPWR sky130_fd_sc_hd__decap_3
XFILLER_0_38_141 VGND VGND VPWR VPWR sky130_fd_sc_hd__fill_1
XFILLER_0_14_69 VGND VGND VPWR VPWR sky130_fd_sc_hd__fill_1
XFILLER_0_53_155 VGND VGND VPWR VPWR sky130_fd_sc_hd__fill_2
X_3162_ net214 VGND VGND VPWR VPWR _1280_ sky130_fd_sc_hd__clkbuf_1
XFILLER_0_39_55 VGND VGND VPWR VPWR sky130_fd_sc_hd__fill_1
X_3231_ net71 _1318_ _1320_ _1302_ VGND VGND VPWR VPWR _0217_ sky130_fd_sc_hd__o211a_1
XTAP_269 VGND VPWR sky130_fd_sc_hd__tapvpwrvgnd_1
X_3300_ _1343_ VGND VGND VPWR VPWR _1368_ sky130_fd_sc_hd__buf_2
XTAP_203 VGND VPWR sky130_fd_sc_hd__tapvpwrvgnd_1
XTAP_214 VGND VPWR sky130_fd_sc_hd__tapvpwrvgnd_1
XTAP_225 VGND VPWR sky130_fd_sc_hd__tapvpwrvgnd_1
XTAP_236 VGND VPWR sky130_fd_sc_hd__tapvpwrvgnd_1
XTAP_247 VGND VPWR sky130_fd_sc_hd__tapvpwrvgnd_1
XTAP_258 VGND VPWR sky130_fd_sc_hd__tapvpwrvgnd_1
XFILLER_0_55_43 VPWR VGND VPWR VGND sky130_ef_sc_hd__decap_12
X_2044_ _1716_ VGND VGND VPWR VPWR _0069_ sky130_fd_sc_hd__clkbuf_1
X_2113_ net95 _0323_ _0328_ _0321_ VGND VGND VPWR VPWR _0091_ sky130_fd_sc_hd__o211a_1
X_3093_ _1153_ _1233_ net278 VGND VGND VPWR VPWR _1237_ sky130_fd_sc_hd__and3b_1
XFILLER_0_12_7 VGND VGND VPWR VPWR sky130_fd_sc_hd__decap_6
X_2946_ _0959_ _0866_ _1120_ _1121_ _1122_ VGND VGND VPWR VPWR _1123_ sky130_fd_sc_hd__a2111o_1
X_2877_ _1027_ _1024_ _1022_ _1020_ VGND VGND VPWR VPWR _1054_ sky130_fd_sc_hd__or4_1
X_1759_ net94 _1482_ _1493_ _1486_ VGND VGND VPWR VPWR _0007_ sky130_fd_sc_hd__o211a_1
X_1828_ uart_rdr\[7\] _1538_ _1550_ VGND VGND VPWR VPWR _1555_ sky130_fd_sc_hd__a21bo_1
X_3429_ net203 _1451_ VGND VGND VPWR VPWR _1457_ sky130_fd_sc_hd__or2_1
XFILLER_0_35_166 VGND VGND VPWR VPWR sky130_fd_sc_hd__fill_2
XFILLER_0_35_144 VGND VGND VPWR VPWR sky130_fd_sc_hd__fill_1
XFILLER_0_35_133 VGND VGND VPWR VPWR sky130_fd_sc_hd__fill_1
XFILLER_0_25_24 VGND VGND VPWR VPWR sky130_fd_sc_hd__decap_6
XFILLER_0_25_13 VGND VGND VPWR VPWR sky130_fd_sc_hd__fill_1
X_2800_ _0441_ RX.baud_cnt\[26\] RX.baud_cnt\[27\] _0455_ VGND VGND VPWR VPWR _0977_
+ sky130_fd_sc_hd__o22a_1
XFILLER_0_26_122 VGND VGND VPWR VPWR sky130_fd_sc_hd__decap_4
X_2731_ _0900_ _0906_ _0907_ VGND VGND VPWR VPWR _0908_ sky130_fd_sc_hd__o21a_1
X_2662_ _0847_ _0848_ _0850_ TX.baud_counter\[15\] VGND VGND VPWR VPWR _0851_ sky130_fd_sc_hd__a22o_1
X_2593_ TX.baud_counter\[22\] _0779_ _0781_ TX.baud_counter\[21\] VGND VGND VPWR VPWR
+ _0782_ sky130_fd_sc_hd__o22a_1
X_3145_ _1271_ VGND VGND VPWR VPWR _0180_ sky130_fd_sc_hd__clkbuf_1
X_3214_ _0352_ _1304_ VGND VGND VPWR VPWR _1310_ sky130_fd_sc_hd__nand2_1
X_2027_ _1690_ RX.rx_shifter\[24\] _1695_ uart_rdr\[24\] VGND VGND VPWR VPWR _1705_
+ sky130_fd_sc_hd__a22o_1
XFILLER_0_15_90 VGND VGND VPWR VPWR sky130_fd_sc_hd__fill_1
X_3076_ _1153_ _1223_ VGND VGND VPWR VPWR _1225_ sky130_fd_sc_hd__nor2_1
X_2929_ _0777_ _0780_ RX.baud_cnt\[21\] VGND VGND VPWR VPWR _1106_ sky130_fd_sc_hd__a21o_1
XFILLER_0_11_15 VGND VGND VPWR VPWR sky130_fd_sc_hd__decap_6
Xinput8 S_AXI_ARADDR[16] VGND VGND VPWR VPWR net8 sky130_fd_sc_hd__buf_1
XFILLER_0_46_206 VGND VGND VPWR VPWR sky130_fd_sc_hd__decap_3
XFILLER_0_52_99 VGND VGND VPWR VPWR sky130_fd_sc_hd__fill_1
X_2714_ net300 _0884_ VGND VGND VPWR VPWR _0893_ sky130_fd_sc_hd__or2_1
X_3694_ clknet_leaf_20_S_AXI_ACLK _0259_ net147 VGND VGND VPWR VPWR TX.baud_counter\[25\]
+ sky130_fd_sc_hd__dfrtp_4
X_2576_ RX.uart_cpb\[31\] _0313_ _0763_ _0764_ _1639_ VGND VGND VPWR VPWR _0765_ sky130_fd_sc_hd__a32o_2
X_2645_ _0828_ _0830_ _0832_ TX.baud_counter\[8\] _0833_ VGND VGND VPWR VPWR _0834_
+ sky130_fd_sc_hd__o221a_1
X_3128_ _1262_ VGND VGND VPWR VPWR _0172_ sky130_fd_sc_hd__clkbuf_1
X_3059_ RX.baud_cnt\[21\] _1211_ VGND VGND VPWR VPWR _1213_ sky130_fd_sc_hd__or2_1
XFILLER_0_13_191 VGND VGND VPWR VPWR sky130_fd_sc_hd__fill_2
XPHY_92 VGND VGND VPWR VPWR sky130_fd_sc_hd__decap_3
XPHY_81 VGND VGND VPWR VPWR sky130_fd_sc_hd__decap_3
XPHY_70 VGND VGND VPWR VPWR sky130_fd_sc_hd__decap_3
XFILLER_0_22_69 VGND VGND VPWR VPWR sky130_fd_sc_hd__fill_2
X_2361_ _0404_ _0408_ _0544_ _0549_ VGND VGND VPWR VPWR _0550_ sky130_fd_sc_hd__o211a_1
X_2430_ RX.uart_cpb\[0\] RX.uart_cpb\[1\] VGND VGND VPWR VPWR _0619_ sky130_fd_sc_hd__and2b_1
X_2292_ net83 _0483_ _0491_ _0487_ VGND VGND VPWR VPWR _0107_ sky130_fd_sc_hd__o211a_1
X_3677_ clknet_leaf_18_S_AXI_ACLK _0242_ net152 VGND VGND VPWR VPWR TX.baud_counter\[8\]
+ sky130_fd_sc_hd__dfrtp_4
Xoutput120 net120 VGND VGND VPWR VPWR S_AXI_RDATA[18] sky130_fd_sc_hd__buf_2
X_2559_ RX.uart_cpb\[30\] VGND VGND VPWR VPWR _0748_ sky130_fd_sc_hd__inv_2
Xoutput131 net131 VGND VGND VPWR VPWR S_AXI_RDATA[28] sky130_fd_sc_hd__clkbuf_4
Xoutput142 net142 VGND VGND VPWR VPWR S_AXI_RDATA[9] sky130_fd_sc_hd__clkbuf_4
X_2628_ TX.baud_counter\[2\] _0810_ VGND VGND VPWR VPWR _0817_ sky130_fd_sc_hd__nand2_1
XFILLER_0_10_194 VGND VGND VPWR VPWR sky130_fd_sc_hd__fill_2
XFILLER_0_0_309 VGND VGND VPWR VPWR sky130_fd_sc_hd__fill_2
XFILLER_0_33_57 VGND VGND VPWR VPWR sky130_fd_sc_hd__decap_6
XFILLER_0_33_13 VGND VGND VPWR VPWR sky130_fd_sc_hd__fill_1
X_1930_ _1485_ VGND VGND VPWR VPWR _1635_ sky130_fd_sc_hd__buf_4
Xinput44 S_AXI_AWADDR[18] VGND VGND VPWR VPWR net44 sky130_fd_sc_hd__clkbuf_1
Xinput22 S_AXI_ARADDR[29] VGND VGND VPWR VPWR net22 sky130_fd_sc_hd__clkbuf_2
X_1861_ RX.uart_cpb\[13\] _1578_ _1579_ _1581_ VGND VGND VPWR VPWR _1582_ sky130_fd_sc_hd__a211o_1
X_3600_ clknet_leaf_11_S_AXI_ACLK _0165_ net159 VGND VGND VPWR VPWR RX.bit_idx\[1\]
+ sky130_fd_sc_hd__dfrtp_4
X_1792_ RX.uart_stp\[1\] VGND VGND VPWR VPWR _1525_ sky130_fd_sc_hd__clkbuf_4
Xinput33 S_AXI_ARESETN VGND VGND VPWR VPWR net33 sky130_fd_sc_hd__clkbuf_1
Xinput11 S_AXI_ARADDR[19] VGND VGND VPWR VPWR net11 sky130_fd_sc_hd__buf_1
Xinput77 S_AXI_WDATA[16] VGND VGND VPWR VPWR net77 sky130_fd_sc_hd__buf_2
Xinput66 S_AXI_AWADDR[9] VGND VGND VPWR VPWR net66 sky130_fd_sc_hd__buf_1
Xinput88 S_AXI_WDATA[26] VGND VGND VPWR VPWR net88 sky130_fd_sc_hd__clkbuf_2
X_3531_ clknet_leaf_13_S_AXI_ACLK _0096_ net157 VGND VGND VPWR VPWR TX.bit_index\[0\]
+ sky130_fd_sc_hd__dfrtp_2
Xinput55 S_AXI_AWADDR[28] VGND VGND VPWR VPWR net55 sky130_fd_sc_hd__buf_1
X_3462_ clknet_leaf_0_S_AXI_ACLK _0027_ VGND VGND VPWR VPWR net121 sky130_fd_sc_hd__dfxtp_1
Xinput99 S_AXI_WDATA[7] VGND VGND VPWR VPWR net99 sky130_fd_sc_hd__dlymetal6s2s_1
X_3393_ TX.baud_counter\[30\] _1434_ VGND VGND VPWR VPWR _1436_ sky130_fd_sc_hd__or2_1
X_2344_ _0531_ _0532_ VGND VGND VPWR VPWR _0533_ sky130_fd_sc_hd__nand2_1
X_2413_ _0514_ _0531_ _0600_ _0589_ VGND VGND VPWR VPWR _0602_ sky130_fd_sc_hd__a31o_1
X_2275_ net187 net109 _1635_ _0480_ VGND VGND VPWR VPWR _0101_ sky130_fd_sc_hd__o211a_1
XFILLER_0_47_334 VGND VGND VPWR VPWR sky130_fd_sc_hd__fill_2
XFILLER_0_30_201 VGND VGND VPWR VPWR sky130_fd_sc_hd__fill_1
XFILLER_0_53_337 VPWR VGND VPWR VGND sky130_ef_sc_hd__decap_12
XTAP_429 VGND VPWR sky130_fd_sc_hd__tapvpwrvgnd_1
XTAP_418 VGND VPWR sky130_fd_sc_hd__tapvpwrvgnd_1
XTAP_407 VGND VPWR sky130_fd_sc_hd__tapvpwrvgnd_1
X_2060_ _0293_ _0290_ VGND VGND VPWR VPWR _0294_ sky130_fd_sc_hd__nand2_1
X_1913_ TX.uart_tdr\[25\] _1604_ _1605_ RX.uart_stp\[25\] VGND VGND VPWR VPWR _1622_
+ sky130_fd_sc_hd__a22o_1
X_2893_ _1065_ _1066_ _1067_ _1068_ _1069_ VGND VGND VPWR VPWR _1070_ sky130_fd_sc_hd__a311o_1
X_2962_ _1138_ _1059_ VGND VGND VPWR VPWR _1139_ sky130_fd_sc_hd__or2b_1
X_1844_ TX.uart_tdr\[10\] _1566_ _1567_ net226 VGND VGND VPWR VPWR _1568_ sky130_fd_sc_hd__a22o_1
X_1775_ _1508_ VGND VGND VPWR VPWR _1509_ sky130_fd_sc_hd__clkbuf_4
X_3514_ clknet_leaf_12_S_AXI_ACLK _0079_ VGND VGND VPWR VPWR RX.uart_cpb\[7\] sky130_fd_sc_hd__dfxtp_1
X_3445_ clknet_leaf_14_S_AXI_ACLK net193 VGND VGND VPWR VPWR net133 sky130_fd_sc_hd__dfxtp_1
X_2258_ _1463_ _0468_ VGND VGND VPWR VPWR _0469_ sky130_fd_sc_hd__or2b_1
X_3376_ TX.baud_counter\[25\] _1421_ _1423_ VGND VGND VPWR VPWR _1424_ sky130_fd_sc_hd__o21a_1
X_2327_ _1553_ RX.uart_cpb\[6\] VGND VGND VPWR VPWR _0516_ sky130_fd_sc_hd__nand2_2
X_2189_ RX.uart_cpb\[14\] _0396_ VGND VGND VPWR VPWR _0400_ sky130_fd_sc_hd__xnor2_2
XFILLER_0_50_307 VGND VGND VPWR VPWR sky130_fd_sc_hd__fill_1
XFILLER_0_38_197 VGND VGND VPWR VPWR sky130_fd_sc_hd__fill_2
X_3161_ _1279_ VGND VGND VPWR VPWR _0188_ sky130_fd_sc_hd__clkbuf_1
X_3230_ _0385_ _1318_ VGND VGND VPWR VPWR _1320_ sky130_fd_sc_hd__nand2_1
X_2112_ net303 _0324_ VGND VGND VPWR VPWR _0328_ sky130_fd_sc_hd__or2_1
XTAP_204 VGND VPWR sky130_fd_sc_hd__tapvpwrvgnd_1
XTAP_215 VGND VPWR sky130_fd_sc_hd__tapvpwrvgnd_1
XTAP_226 VGND VPWR sky130_fd_sc_hd__tapvpwrvgnd_1
XTAP_237 VGND VPWR sky130_fd_sc_hd__tapvpwrvgnd_1
XTAP_248 VGND VPWR sky130_fd_sc_hd__tapvpwrvgnd_1
XTAP_259 VGND VPWR sky130_fd_sc_hd__tapvpwrvgnd_1
XFILLER_0_55_55 VGND VGND VPWR VPWR sky130_fd_sc_hd__fill_1
X_2043_ _1700_ _1715_ VGND VGND VPWR VPWR _1716_ sky130_fd_sc_hd__and2_1
X_3092_ RX.baud_cnt\[30\] _1235_ _1236_ _1154_ VGND VGND VPWR VPWR _0162_ sky130_fd_sc_hd__o22a_1
XFILLER_0_32_329 VGND VGND VPWR VPWR sky130_fd_sc_hd__fill_1
X_2945_ RX.baud_cnt\[24\] _0773_ VGND VGND VPWR VPWR _1122_ sky130_fd_sc_hd__and2_1
X_2876_ _0297_ RX.baud_cnt\[1\] _1052_ VGND VGND VPWR VPWR _1053_ sky130_fd_sc_hd__o21ai_1
X_1827_ TX.data_latch_next\[7\] _1507_ _1509_ RX.uart_stp\[7\] VGND VGND VPWR VPWR
+ _1554_ sky130_fd_sc_hd__a22o_1
X_3428_ net73 _1450_ _1456_ _1336_ VGND VGND VPWR VPWR _0278_ sky130_fd_sc_hd__o211a_1
X_1758_ net200 _1483_ VGND VGND VPWR VPWR _1493_ sky130_fd_sc_hd__or2_1
XFILLER_0_4_253 VGND VGND VPWR VPWR sky130_fd_sc_hd__fill_2
XFILLER_0_20_91 VGND VGND VPWR VPWR sky130_fd_sc_hd__fill_1
X_3359_ _1369_ _1409_ _1411_ _1403_ net306 VGND VGND VPWR VPWR _0254_ sky130_fd_sc_hd__a32o_1
X_2661_ _0599_ _0849_ VGND VGND VPWR VPWR _0850_ sky130_fd_sc_hd__xnor2_4
X_2730_ RX.baud_cnt\[20\] _0354_ _0351_ RX.baud_cnt\[21\] VGND VGND VPWR VPWR _0907_
+ sky130_fd_sc_hd__o22a_1
X_2592_ _0777_ _0780_ VGND VGND VPWR VPWR _0781_ sky130_fd_sc_hd__and2_1
X_3144_ net208 VGND VGND VPWR VPWR _1271_ sky130_fd_sc_hd__clkbuf_1
X_3213_ net80 _1305_ _1309_ _1302_ VGND VGND VPWR VPWR _0210_ sky130_fd_sc_hd__o211a_1
X_3075_ _1194_ _1223_ _1224_ _1186_ RX.baud_cnt\[25\] VGND VGND VPWR VPWR _0157_ sky130_fd_sc_hd__a32o_1
XFILLER_0_57_281 VGND VGND VPWR VPWR sky130_fd_sc_hd__fill_2
X_2026_ _1704_ VGND VGND VPWR VPWR _0063_ sky130_fd_sc_hd__clkbuf_1
XFILLER_0_15_80 VGND VGND VPWR VPWR sky130_fd_sc_hd__fill_1
XFILLER_0_32_126 VGND VGND VPWR VPWR sky130_fd_sc_hd__fill_2
X_2859_ _0408_ _0936_ VGND VGND VPWR VPWR _1036_ sky130_fd_sc_hd__and2_1
X_2928_ _0897_ _0779_ _1104_ VGND VGND VPWR VPWR _1105_ sky130_fd_sc_hd__a21o_1
XFILLER_0_17_134 VGND VGND VPWR VPWR sky130_fd_sc_hd__fill_1
XFILLER_0_36_79 VGND VGND VPWR VPWR sky130_fd_sc_hd__fill_2
Xinput9 S_AXI_ARADDR[17] VGND VGND VPWR VPWR net9 sky130_fd_sc_hd__clkbuf_1
XFILLER_0_52_67 VGND VGND VPWR VPWR sky130_fd_sc_hd__fill_1
XFILLER_0_52_56 VGND VGND VPWR VPWR sky130_fd_sc_hd__decap_4
X_2713_ net84 _0883_ _0892_ _0890_ VGND VGND VPWR VPWR _0127_ sky130_fd_sc_hd__o211a_1
XFILLER_0_6_315 VGND VGND VPWR VPWR sky130_fd_sc_hd__decap_3
X_3693_ clknet_leaf_21_S_AXI_ACLK _0258_ net147 VGND VGND VPWR VPWR TX.baud_counter\[24\]
+ sky130_fd_sc_hd__dfrtp_4
X_2644_ TX.baud_counter\[7\] _0829_ VGND VGND VPWR VPWR _0833_ sky130_fd_sc_hd__or2_1
XFILLER_0_14_115 VGND VGND VPWR VPWR sky130_fd_sc_hd__decap_3
X_2575_ _0449_ RX.uart_stp\[0\] _0757_ _1526_ VGND VGND VPWR VPWR _0764_ sky130_fd_sc_hd__a31o_1
X_3127_ net107 net316 _1261_ VGND VGND VPWR VPWR _1262_ sky130_fd_sc_hd__mux2_1
X_3058_ _1194_ _1210_ _1212_ _1186_ RX.baud_cnt\[20\] VGND VGND VPWR VPWR _0152_ sky130_fd_sc_hd__a32o_1
X_2009_ _1692_ VGND VGND VPWR VPWR _0058_ sky130_fd_sc_hd__clkbuf_1
XPHY_82 VGND VGND VPWR VPWR sky130_fd_sc_hd__decap_3
XPHY_71 VGND VGND VPWR VPWR sky130_fd_sc_hd__decap_3
XPHY_60 VGND VGND VPWR VPWR sky130_fd_sc_hd__decap_3
XPHY_93 VGND VGND VPWR VPWR sky130_fd_sc_hd__decap_3
XFILLER_0_36_251 VGND VGND VPWR VPWR sky130_fd_sc_hd__fill_1
X_2291_ net205 _0484_ VGND VGND VPWR VPWR _0491_ sky130_fd_sc_hd__or2_1
X_2360_ _0538_ _0541_ _0543_ _0546_ VGND VGND VPWR VPWR _0549_ sky130_fd_sc_hd__a211o_1
XFILLER_0_2_69 VGND VGND VPWR VPWR sky130_fd_sc_hd__decap_6
Xoutput143 net143 VGND VGND VPWR VPWR S_AXI_RVALID sky130_fd_sc_hd__clkbuf_4
X_3676_ clknet_leaf_19_S_AXI_ACLK _0241_ net151 VGND VGND VPWR VPWR TX.baud_counter\[7\]
+ sky130_fd_sc_hd__dfrtp_4
Xoutput110 net110 VGND VGND VPWR VPWR S_AXI_BVALID sky130_fd_sc_hd__clkbuf_4
X_2627_ TX.baud_counter\[0\] _0624_ VGND VGND VPWR VPWR _0816_ sky130_fd_sc_hd__nor2_1
Xoutput121 net121 VGND VGND VPWR VPWR S_AXI_RDATA[19] sky130_fd_sc_hd__clkbuf_4
Xoutput132 net132 VGND VGND VPWR VPWR S_AXI_RDATA[29] sky130_fd_sc_hd__clkbuf_4
X_2558_ _1639_ RX.uart_cpb\[29\] VGND VGND VPWR VPWR _0747_ sky130_fd_sc_hd__nor2_1
X_2489_ _0548_ _0550_ _0552_ VGND VGND VPWR VPWR _0678_ sky130_fd_sc_hd__nand3_1
XFILLER_0_10_173 VGND VGND VPWR VPWR sky130_fd_sc_hd__fill_2
X_1860_ uart_rdr\[13\] _1580_ _1550_ VGND VGND VPWR VPWR _1581_ sky130_fd_sc_hd__a21bo_1
Xinput78 S_AXI_WDATA[17] VGND VGND VPWR VPWR net78 sky130_fd_sc_hd__clkbuf_2
Xinput34 S_AXI_ARVALID VGND VGND VPWR VPWR net34 sky130_fd_sc_hd__buf_1
Xinput12 S_AXI_ARADDR[1] VGND VGND VPWR VPWR net12 sky130_fd_sc_hd__dlymetal6s2s_1
X_3461_ clknet_leaf_7_S_AXI_ACLK _0026_ VGND VGND VPWR VPWR net120 sky130_fd_sc_hd__dfxtp_1
Xinput23 S_AXI_ARADDR[2] VGND VGND VPWR VPWR net23 sky130_fd_sc_hd__buf_1
Xinput89 S_AXI_WDATA[27] VGND VGND VPWR VPWR net89 sky130_fd_sc_hd__clkbuf_2
Xinput56 S_AXI_AWADDR[29] VGND VGND VPWR VPWR net56 sky130_fd_sc_hd__buf_1
Xinput45 S_AXI_AWADDR[19] VGND VGND VPWR VPWR net45 sky130_fd_sc_hd__clkbuf_2
X_3530_ clknet_leaf_14_S_AXI_ACLK _0095_ VGND VGND VPWR VPWR TX.data_latch_next\[7\]
+ sky130_fd_sc_hd__dfxtp_1
Xinput67 S_AXI_AWVALID VGND VGND VPWR VPWR net67 sky130_fd_sc_hd__clkbuf_1
X_1791_ _1495_ net276 _1515_ _1523_ _1524_ VGND VGND VPWR VPWR _0008_ sky130_fd_sc_hd__o221a_1
X_2274_ net187 net68 VGND VGND VPWR VPWR _0480_ sky130_fd_sc_hd__nand2_1
X_3392_ _1342_ _1364_ _1435_ _1403_ net264 VGND VGND VPWR VPWR _0263_ sky130_fd_sc_hd__a32o_1
X_2343_ _1562_ RX.uart_cpb\[8\] VGND VGND VPWR VPWR _0532_ sky130_fd_sc_hd__or2_1
X_2412_ _0531_ _0600_ _0514_ VGND VGND VPWR VPWR _0601_ sky130_fd_sc_hd__a21oi_1
X_1989_ _1677_ _1678_ VGND VGND VPWR VPWR _1679_ sky130_fd_sc_hd__and2_1
XFILLER_0_47_346 VGND VGND VPWR VPWR sky130_fd_sc_hd__fill_1
XFILLER_0_15_243 VGND VGND VPWR VPWR sky130_fd_sc_hd__decap_3
X_3659_ clknet_leaf_0_S_AXI_ACLK _0224_ VGND VGND VPWR VPWR RX.uart_stp\[25\] sky130_fd_sc_hd__dfxtp_1
XFILLER_0_38_346 VGND VGND VPWR VPWR sky130_fd_sc_hd__fill_2
XFILLER_0_53_349 VGND VGND VPWR VPWR sky130_fd_sc_hd__decap_8
XTAP_419 VGND VPWR sky130_fd_sc_hd__tapvpwrvgnd_1
XTAP_408 VGND VPWR sky130_fd_sc_hd__tapvpwrvgnd_1
XFILLER_0_28_36 VGND VGND VPWR VPWR sky130_fd_sc_hd__decap_4
XFILLER_0_21_279 VGND VGND VPWR VPWR sky130_fd_sc_hd__fill_1
X_1912_ _1609_ net176 _1600_ _1621_ VGND VGND VPWR VPWR _0032_ sky130_fd_sc_hd__o211a_1
X_1843_ _1508_ VGND VGND VPWR VPWR _1567_ sky130_fd_sc_hd__clkbuf_4
XFILLER_0_29_346 VGND VGND VPWR VPWR sky130_fd_sc_hd__fill_2
X_2961_ _1064_ _1137_ _1068_ _1067_ VGND VGND VPWR VPWR _1138_ sky130_fd_sc_hd__or4b_1
X_2892_ RX.baud_cnt\[5\] _0823_ VGND VGND VPWR VPWR _1069_ sky130_fd_sc_hd__nor2_1
X_1774_ net26 _1503_ _1505_ VGND VGND VPWR VPWR _1508_ sky130_fd_sc_hd__and3b_2
X_3513_ clknet_leaf_15_S_AXI_ACLK _0078_ VGND VGND VPWR VPWR RX.uart_cpb\[6\] sky130_fd_sc_hd__dfxtp_4
X_3444_ clknet_leaf_12_S_AXI_ACLK _0009_ VGND VGND VPWR VPWR net122 sky130_fd_sc_hd__dfxtp_1
X_3375_ TX.baud_counter\[25\] _1421_ _1352_ VGND VGND VPWR VPWR _1423_ sky130_fd_sc_hd__a21oi_1
X_2257_ _0446_ _0464_ _0467_ VGND VGND VPWR VPWR _0468_ sky130_fd_sc_hd__a21o_2
X_2326_ _0514_ VGND VGND VPWR VPWR _0515_ sky130_fd_sc_hd__inv_2
XFILLER_0_47_121 VGND VGND VPWR VPWR sky130_fd_sc_hd__fill_2
X_2188_ TX.baud_counter\[12\] _0393_ _0398_ TX.baud_counter\[13\] VGND VGND VPWR VPWR
+ _0399_ sky130_fd_sc_hd__a22o_1
XFILLER_0_30_59 VGND VGND VPWR VPWR sky130_fd_sc_hd__decap_3
XTAP_205 VGND VPWR sky130_fd_sc_hd__tapvpwrvgnd_1
X_3160_ net215 VGND VGND VPWR VPWR _1279_ sky130_fd_sc_hd__clkbuf_1
Xhold1 net125 VGND VGND VPWR VPWR net168 sky130_fd_sc_hd__dlygate4sd3_1
X_2042_ RX.done_reg RX.rx_shifter\[29\] _1695_ uart_rdr\[29\] VGND VGND VPWR VPWR
+ _1715_ sky130_fd_sc_hd__a22o_1
X_3091_ RX.baud_cnt\[30\] _1233_ _1176_ VGND VGND VPWR VPWR _1236_ sky130_fd_sc_hd__a21oi_1
XTAP_216 VGND VPWR sky130_fd_sc_hd__tapvpwrvgnd_1
XTAP_227 VGND VPWR sky130_fd_sc_hd__tapvpwrvgnd_1
X_2111_ net92 _0323_ _0327_ _0321_ VGND VGND VPWR VPWR _0090_ sky130_fd_sc_hd__o211a_1
XTAP_238 VGND VPWR sky130_fd_sc_hd__tapvpwrvgnd_1
XTAP_249 VGND VPWR sky130_fd_sc_hd__tapvpwrvgnd_1
XFILLER_0_29_121 VGND VGND VPWR VPWR sky130_fd_sc_hd__fill_2
XFILLER_0_29_110 VGND VGND VPWR VPWR sky130_fd_sc_hd__fill_2
XFILLER_0_44_168 VGND VGND VPWR VPWR sky130_fd_sc_hd__fill_1
XFILLER_0_44_157 VGND VGND VPWR VPWR sky130_fd_sc_hd__decap_3
X_2944_ RX.baud_cnt\[25\] _0775_ _0773_ RX.baud_cnt\[24\] VGND VGND VPWR VPWR _1121_
+ sky130_fd_sc_hd__o22ai_1
XFILLER_0_4_276 VGND VGND VPWR VPWR sky130_fd_sc_hd__fill_2
Xclkbuf_leaf_16_S_AXI_ACLK clknet_1_1__leaf_S_AXI_ACLK VGND VGND VPWR VPWR clknet_leaf_16_S_AXI_ACLK
+ sky130_fd_sc_hd__clkbuf_16
X_2875_ _1557_ _1026_ RX.baud_cnt\[0\] _0293_ _1019_ VGND VGND VPWR VPWR _1052_ sky130_fd_sc_hd__o221a_1
X_1826_ RX.uart_cpb\[7\] VGND VGND VPWR VPWR _1553_ sky130_fd_sc_hd__clkbuf_4
X_1757_ net93 _1482_ _1492_ _1486_ VGND VGND VPWR VPWR _0006_ sky130_fd_sc_hd__o211a_1
X_3427_ net213 _1451_ VGND VGND VPWR VPWR _1456_ sky130_fd_sc_hd__or2_1
X_3358_ _1381_ _1410_ VGND VGND VPWR VPWR _1411_ sky130_fd_sc_hd__nor2_1
X_2309_ net72 _0496_ _0501_ _0502_ VGND VGND VPWR VPWR _0113_ sky130_fd_sc_hd__o211a_1
X_3289_ TX.baud_counter\[3\] _1357_ VGND VGND VPWR VPWR _1359_ sky130_fd_sc_hd__or2_1
XFILLER_0_35_124 VGND VGND VPWR VPWR sky130_fd_sc_hd__fill_2
XFILLER_0_50_149 VGND VGND VPWR VPWR sky130_fd_sc_hd__fill_1
X_2660_ _0800_ _0674_ VGND VGND VPWR VPWR _0849_ sky130_fd_sc_hd__or2b_2
X_3212_ _0419_ _1304_ VGND VGND VPWR VPWR _1309_ sky130_fd_sc_hd__nand2_1
X_2591_ _0690_ _0701_ _0699_ VGND VGND VPWR VPWR _0780_ sky130_fd_sc_hd__a21o_1
X_2025_ _1700_ _1703_ VGND VGND VPWR VPWR _1704_ sky130_fd_sc_hd__and2_1
X_3143_ _1270_ VGND VGND VPWR VPWR _0179_ sky130_fd_sc_hd__clkbuf_1
X_3074_ RX.baud_cnt\[25\] _1221_ _1163_ VGND VGND VPWR VPWR _1224_ sky130_fd_sc_hd__o21a_1
X_2927_ RX.baud_cnt\[21\] _0777_ _0780_ VGND VGND VPWR VPWR _1104_ sky130_fd_sc_hd__and3_1
XFILLER_0_32_105 VGND VGND VPWR VPWR sky130_fd_sc_hd__fill_2
X_1809_ _1535_ _1536_ _1537_ _1539_ VGND VGND VPWR VPWR _1540_ sky130_fd_sc_hd__a211o_1
X_2789_ RX.baud_cnt\[30\] _0453_ _0964_ _0965_ VGND VGND VPWR VPWR _0966_ sky130_fd_sc_hd__o22a_1
XFILLER_0_13_363 VGND VGND VPWR VPWR sky130_fd_sc_hd__fill_1
X_2858_ _0535_ RX.baud_cnt\[10\] RX.baud_cnt\[9\] _0385_ _1034_ VGND VGND VPWR VPWR
+ _1035_ sky130_fd_sc_hd__a221o_1
XFILLER_0_23_138 VGND VGND VPWR VPWR sky130_fd_sc_hd__decap_4
X_2712_ net269 _0884_ VGND VGND VPWR VPWR _0892_ sky130_fd_sc_hd__or2_1
X_2574_ _1639_ _0757_ RX.uart_stp\[0\] VGND VGND VPWR VPWR _0763_ sky130_fd_sc_hd__o21ai_1
X_3692_ clknet_leaf_20_S_AXI_ACLK _0257_ net148 VGND VGND VPWR VPWR TX.baud_counter\[23\]
+ sky130_fd_sc_hd__dfrtp_4
X_2643_ _0806_ _0831_ VGND VGND VPWR VPWR _0832_ sky130_fd_sc_hd__nor2_1
XFILLER_0_22_160 VGND VGND VPWR VPWR sky130_fd_sc_hd__fill_2
X_2008_ _1677_ _1691_ VGND VGND VPWR VPWR _1692_ sky130_fd_sc_hd__and2_1
X_3126_ _1258_ RX.bit_idx\[1\] _0970_ VGND VGND VPWR VPWR _1261_ sky130_fd_sc_hd__or3b_1
XFILLER_0_26_80 VGND VGND VPWR VPWR sky130_fd_sc_hd__decap_4
X_3057_ _0974_ _1211_ VGND VGND VPWR VPWR _1212_ sky130_fd_sc_hd__nor2_1
Xclkbuf_leaf_6_S_AXI_ACLK clknet_1_1__leaf_S_AXI_ACLK VGND VGND VPWR VPWR clknet_leaf_6_S_AXI_ACLK
+ sky130_fd_sc_hd__clkbuf_16
XFILLER_0_9_110 VGND VGND VPWR VPWR sky130_fd_sc_hd__fill_2
XPHY_94 VGND VGND VPWR VPWR sky130_fd_sc_hd__decap_3
XPHY_83 VGND VGND VPWR VPWR sky130_fd_sc_hd__decap_3
XPHY_72 VGND VGND VPWR VPWR sky130_fd_sc_hd__decap_3
XPHY_61 VGND VGND VPWR VPWR sky130_fd_sc_hd__decap_3
XPHY_50 VGND VGND VPWR VPWR sky130_fd_sc_hd__decap_3
XFILLER_0_51_222 VGND VGND VPWR VPWR sky130_fd_sc_hd__fill_2
XFILLER_0_3_308 VPWR VGND VPWR VGND sky130_ef_sc_hd__decap_12
X_2290_ net82 _0483_ _0490_ _0487_ VGND VGND VPWR VPWR _0106_ sky130_fd_sc_hd__o211a_1
Xoutput144 net144 VGND VGND VPWR VPWR S_AXI_WREADY sky130_fd_sc_hd__buf_2
X_2557_ _0441_ _0313_ _0604_ _0455_ _0745_ VGND VGND VPWR VPWR _0746_ sky130_fd_sc_hd__o221a_2
Xoutput133 net133 VGND VGND VPWR VPWR S_AXI_RDATA[2] sky130_fd_sc_hd__clkbuf_4
Xoutput122 net122 VGND VGND VPWR VPWR S_AXI_RDATA[1] sky130_fd_sc_hd__clkbuf_4
Xoutput111 net111 VGND VGND VPWR VPWR S_AXI_RDATA[0] sky130_fd_sc_hd__clkbuf_4
X_2626_ _0813_ _0814_ TX.baud_counter\[1\] VGND VGND VPWR VPWR _0815_ sky130_fd_sc_hd__a21oi_1
X_3675_ clknet_leaf_18_S_AXI_ACLK _0240_ net151 VGND VGND VPWR VPWR TX.baud_counter\[6\]
+ sky130_fd_sc_hd__dfrtp_2
XFILLER_0_10_141 VGND VGND VPWR VPWR sky130_fd_sc_hd__fill_2
X_2488_ _0548_ _0550_ _0552_ VGND VGND VPWR VPWR _0677_ sky130_fd_sc_hd__a21o_1
X_3109_ _1248_ VGND VGND VPWR VPWR _0167_ sky130_fd_sc_hd__clkbuf_1
Xinput13 S_AXI_ARADDR[20] VGND VGND VPWR VPWR net13 sky130_fd_sc_hd__buf_1
X_1790_ _1485_ VGND VGND VPWR VPWR _1524_ sky130_fd_sc_hd__clkbuf_4
X_3460_ clknet_leaf_7_S_AXI_ACLK _0025_ VGND VGND VPWR VPWR net119 sky130_fd_sc_hd__dfxtp_1
Xinput46 S_AXI_AWADDR[1] VGND VGND VPWR VPWR net46 sky130_fd_sc_hd__buf_1
Xinput35 S_AXI_AWADDR[0] VGND VGND VPWR VPWR net35 sky130_fd_sc_hd__buf_1
Xinput79 S_AXI_WDATA[18] VGND VGND VPWR VPWR net79 sky130_fd_sc_hd__buf_1
Xinput24 S_AXI_ARADDR[30] VGND VGND VPWR VPWR net24 sky130_fd_sc_hd__buf_1
Xinput68 S_AXI_BREADY VGND VGND VPWR VPWR net68 sky130_fd_sc_hd__clkbuf_1
Xinput57 S_AXI_AWADDR[2] VGND VGND VPWR VPWR net57 sky130_fd_sc_hd__dlymetal6s2s_1
X_3391_ _1433_ _1434_ VGND VGND VPWR VPWR _1435_ sky130_fd_sc_hd__nor2_1
X_2411_ _0530_ _0533_ VGND VGND VPWR VPWR _0600_ sky130_fd_sc_hd__or2_1
X_2273_ net184 _1534_ _1635_ _0479_ VGND VGND VPWR VPWR _0100_ sky130_fd_sc_hd__o211a_1
X_2342_ _1562_ RX.uart_cpb\[8\] VGND VGND VPWR VPWR _0531_ sky130_fd_sc_hd__nand2_1
X_1988_ _1667_ RX.rx_shifter\[12\] _1672_ uart_rdr\[12\] VGND VGND VPWR VPWR _1678_
+ sky130_fd_sc_hd__a22o_1
X_3658_ clknet_leaf_4_S_AXI_ACLK _0223_ VGND VGND VPWR VPWR RX.uart_stp\[24\] sky130_fd_sc_hd__dfxtp_1
X_2609_ _0795_ _0797_ VGND VGND VPWR VPWR _0798_ sky130_fd_sc_hd__and2_1
XFILLER_0_30_269 VGND VGND VPWR VPWR sky130_fd_sc_hd__fill_2
X_3589_ clknet_leaf_21_S_AXI_ACLK _0154_ net147 VGND VGND VPWR VPWR RX.baud_cnt\[22\]
+ sky130_fd_sc_hd__dfrtp_1
XFILLER_0_21_236 VGND VGND VPWR VPWR sky130_fd_sc_hd__fill_1
XTAP_409 VGND VPWR sky130_fd_sc_hd__tapvpwrvgnd_1
X_2960_ _1061_ _1136_ _1066_ _1060_ VGND VGND VPWR VPWR _1137_ sky130_fd_sc_hd__or4bb_1
XFILLER_0_52_350 VGND VGND VPWR VPWR sky130_fd_sc_hd__decap_4
X_1911_ RX.uart_cpb\[24\] _1521_ _1619_ _1620_ VGND VGND VPWR VPWR _1621_ sky130_fd_sc_hd__a211o_1
X_1842_ _1506_ VGND VGND VPWR VPWR _1566_ sky130_fd_sc_hd__clkbuf_4
X_1773_ _1506_ VGND VGND VPWR VPWR _1507_ sky130_fd_sc_hd__clkbuf_4
X_2891_ RX.baud_cnt\[4\] _0820_ VGND VGND VPWR VPWR _1068_ sky130_fd_sc_hd__nor2_1
X_3374_ _1364_ _1420_ _1422_ _1403_ net261 VGND VGND VPWR VPWR _0258_ sky130_fd_sc_hd__a32o_1
X_3512_ clknet_leaf_14_S_AXI_ACLK _0077_ VGND VGND VPWR VPWR RX.uart_cpb\[5\] sky130_fd_sc_hd__dfxtp_1
X_3443_ clknet_leaf_12_S_AXI_ACLK _0008_ VGND VGND VPWR VPWR net111 sky130_fd_sc_hd__dfxtp_1
X_2325_ RX.uart_cpb\[10\] RX.uart_cpb\[9\] VGND VGND VPWR VPWR _0514_ sky130_fd_sc_hd__xor2_2
X_2187_ _0396_ _0397_ VGND VGND VPWR VPWR _0398_ sky130_fd_sc_hd__nor2_2
X_2256_ _0465_ _0459_ _0462_ _0461_ _0466_ VGND VGND VPWR VPWR _0467_ sky130_fd_sc_hd__a41o_1
XFILLER_0_34_91 VGND VGND VPWR VPWR sky130_fd_sc_hd__fill_2
XFILLER_0_34_80 VGND VGND VPWR VPWR sky130_fd_sc_hd__fill_1
XFILLER_0_7_241 VGND VGND VPWR VPWR sky130_fd_sc_hd__fill_1
XFILLER_0_14_39 VGND VGND VPWR VPWR sky130_fd_sc_hd__decap_6
XFILLER_0_30_27 VGND VGND VPWR VPWR sky130_fd_sc_hd__fill_1
XTAP_206 VGND VPWR sky130_fd_sc_hd__tapvpwrvgnd_1
XTAP_217 VGND VPWR sky130_fd_sc_hd__tapvpwrvgnd_1
XTAP_228 VGND VPWR sky130_fd_sc_hd__tapvpwrvgnd_1
XTAP_239 VGND VPWR sky130_fd_sc_hd__tapvpwrvgnd_1
XFILLER_0_55_57 VGND VGND VPWR VPWR sky130_fd_sc_hd__fill_1
X_2041_ _1714_ VGND VGND VPWR VPWR _0068_ sky130_fd_sc_hd__clkbuf_1
X_3090_ _1152_ _1233_ VGND VGND VPWR VPWR _1235_ sky130_fd_sc_hd__and2b_1
Xhold2 net138 VGND VGND VPWR VPWR net169 sky130_fd_sc_hd__dlygate4sd3_1
X_2110_ net318 _0324_ VGND VGND VPWR VPWR _0327_ sky130_fd_sc_hd__or2_1
X_2943_ RX.baud_cnt\[26\] _0861_ _0775_ RX.baud_cnt\[25\] VGND VGND VPWR VPWR _1120_
+ sky130_fd_sc_hd__a22o_1
X_1756_ net197 _1483_ VGND VGND VPWR VPWR _1492_ sky130_fd_sc_hd__or2_1
X_2874_ RX.baud_cnt\[31\] _0987_ _0988_ _0994_ _1050_ VGND VGND VPWR VPWR _1051_ sky130_fd_sc_hd__o32a_1
XFILLER_0_4_233 VGND VGND VPWR VPWR sky130_fd_sc_hd__decap_4
X_1825_ _1534_ net185 _1524_ _1552_ VGND VGND VPWR VPWR _0014_ sky130_fd_sc_hd__o211a_1
X_3426_ net72 _1450_ _1455_ _1336_ VGND VGND VPWR VPWR _0277_ sky130_fd_sc_hd__o211a_1
X_2308_ _0295_ VGND VGND VPWR VPWR _0502_ sky130_fd_sc_hd__clkbuf_4
X_3357_ TX.baud_counter\[20\] TX.baud_counter\[19\] _1405_ VGND VGND VPWR VPWR _1410_
+ sky130_fd_sc_hd__and3_1
X_2239_ _0449_ _1639_ _0447_ VGND VGND VPWR VPWR _0450_ sky130_fd_sc_hd__or3_1
X_3288_ _1350_ _1356_ _1358_ _1355_ TX.baud_counter\[2\] VGND VGND VPWR VPWR _0236_
+ sky130_fd_sc_hd__a32o_1
XFILLER_0_0_70 VGND VGND VPWR VPWR sky130_fd_sc_hd__fill_2
X_2590_ _0690_ _0702_ _0777_ _0778_ VGND VGND VPWR VPWR _0779_ sky130_fd_sc_hd__a22oi_4
X_3142_ net202 VGND VGND VPWR VPWR _1270_ sky130_fd_sc_hd__clkbuf_1
X_3211_ net79 _1305_ _1308_ _1302_ VGND VGND VPWR VPWR _0209_ sky130_fd_sc_hd__o211a_1
X_2024_ _1690_ RX.rx_shifter\[23\] _1695_ uart_rdr\[23\] VGND VGND VPWR VPWR _1703_
+ sky130_fd_sc_hd__a22o_1
XFILLER_0_10_7 VPWR VGND VPWR VGND sky130_ef_sc_hd__decap_12
X_3073_ RX.baud_cnt\[25\] _1221_ VGND VGND VPWR VPWR _1223_ sky130_fd_sc_hd__nand2_1
XFILLER_0_17_169 VGND VGND VPWR VPWR sky130_fd_sc_hd__fill_1
X_2926_ _0895_ _0786_ _0779_ _0897_ VGND VGND VPWR VPWR _1103_ sky130_fd_sc_hd__o22ai_2
X_2857_ RX.baud_cnt\[8\] _0649_ RX.uart_cpb\[10\] _1033_ VGND VGND VPWR VPWR _1034_
+ sky130_fd_sc_hd__a2bb2o_1
X_1739_ _1479_ _1480_ VGND VGND VPWR VPWR _1481_ sky130_fd_sc_hd__or2_1
X_1808_ uart_rdr\[3\] _1538_ _1495_ VGND VGND VPWR VPWR _1539_ sky130_fd_sc_hd__a21bo_1
X_2788_ RX.baud_cnt\[30\] _0453_ _0458_ RX.baud_cnt\[29\] VGND VGND VPWR VPWR _0965_
+ sky130_fd_sc_hd__a22o_1
X_3409_ net324 VGND VGND VPWR VPWR _0270_ sky130_fd_sc_hd__clkbuf_1
X_2711_ net83 _0883_ _0891_ _0890_ VGND VGND VPWR VPWR _0126_ sky130_fd_sc_hd__o211a_1
X_2573_ _0755_ _0761_ VGND VGND VPWR VPWR _0762_ sky130_fd_sc_hd__nor2_2
X_3691_ clknet_leaf_20_S_AXI_ACLK _0256_ net147 VGND VGND VPWR VPWR TX.baud_counter\[22\]
+ sky130_fd_sc_hd__dfrtp_4
XFILLER_0_10_312 VGND VGND VPWR VPWR sky130_fd_sc_hd__fill_1
X_2642_ _0640_ _0644_ _0647_ VGND VGND VPWR VPWR _0831_ sky130_fd_sc_hd__a21oi_1
XFILLER_0_22_194 VGND VGND VPWR VPWR sky130_fd_sc_hd__fill_2
X_3125_ _1260_ VGND VGND VPWR VPWR _0171_ sky130_fd_sc_hd__clkbuf_1
X_2007_ _1690_ RX.rx_shifter\[18\] _1672_ uart_rdr\[18\] VGND VGND VPWR VPWR _1691_
+ sky130_fd_sc_hd__a22o_1
XFILLER_0_26_70 VGND VGND VPWR VPWR sky130_fd_sc_hd__fill_1
X_3056_ RX.baud_cnt\[20\] _0904_ _1207_ VGND VGND VPWR VPWR _1211_ sky130_fd_sc_hd__and3_1
XFILLER_0_9_166 VGND VGND VPWR VPWR sky130_fd_sc_hd__fill_2
X_2909_ _1076_ _1077_ _1083_ _1085_ VGND VGND VPWR VPWR _1086_ sky130_fd_sc_hd__or4b_1
XFILLER_0_13_183 VGND VGND VPWR VPWR sky130_fd_sc_hd__fill_2
XPHY_95 VGND VGND VPWR VPWR sky130_fd_sc_hd__decap_3
XPHY_84 VGND VGND VPWR VPWR sky130_fd_sc_hd__decap_3
XPHY_73 VGND VGND VPWR VPWR sky130_fd_sc_hd__decap_3
XFILLER_0_36_253 VGND VGND VPWR VPWR sky130_fd_sc_hd__fill_1
XPHY_62 VGND VGND VPWR VPWR sky130_fd_sc_hd__decap_3
XPHY_51 VGND VGND VPWR VPWR sky130_fd_sc_hd__decap_3
XPHY_40 VGND VGND VPWR VPWR sky130_fd_sc_hd__decap_3
X_3674_ clknet_leaf_18_S_AXI_ACLK _0239_ net152 VGND VGND VPWR VPWR TX.baud_counter\[5\]
+ sky130_fd_sc_hd__dfrtp_2
X_2556_ _0743_ _0589_ _0744_ VGND VGND VPWR VPWR _0745_ sky130_fd_sc_hd__or3b_1
Xoutput112 net112 VGND VGND VPWR VPWR S_AXI_RDATA[10] sky130_fd_sc_hd__clkbuf_4
Xoutput134 net134 VGND VGND VPWR VPWR S_AXI_RDATA[30] sky130_fd_sc_hd__clkbuf_4
X_2487_ _0675_ VGND VGND VPWR VPWR _0676_ sky130_fd_sc_hd__buf_2
Xoutput145 net145 VGND VGND VPWR VPWR uart_tx_o sky130_fd_sc_hd__clkbuf_4
XFILLER_0_2_353 VGND VGND VPWR VPWR sky130_fd_sc_hd__fill_1
Xoutput123 net123 VGND VGND VPWR VPWR S_AXI_RDATA[20] sky130_fd_sc_hd__clkbuf_4
X_2625_ TX.baud_counter\[0\] _0623_ VGND VGND VPWR VPWR _0814_ sky130_fd_sc_hd__or2_1
X_3108_ net107 net326 _1247_ VGND VGND VPWR VPWR _1248_ sky130_fd_sc_hd__mux2_1
X_3039_ RX.baud_cnt\[14\] _1197_ _1199_ VGND VGND VPWR VPWR _0146_ sky130_fd_sc_hd__o21a_1
XFILLER_0_18_242 VGND VGND VPWR VPWR sky130_fd_sc_hd__decap_4
XFILLER_0_18_253 VGND VGND VPWR VPWR sky130_fd_sc_hd__fill_2
XFILLER_0_33_49 VGND VGND VPWR VPWR sky130_fd_sc_hd__decap_4
XFILLER_0_56_315 VPWR VGND VPWR VGND sky130_ef_sc_hd__decap_12
Xinput14 S_AXI_ARADDR[21] VGND VGND VPWR VPWR net14 sky130_fd_sc_hd__buf_1
XFILLER_0_24_234 VGND VGND VPWR VPWR sky130_fd_sc_hd__fill_2
XFILLER_0_24_223 VGND VGND VPWR VPWR sky130_fd_sc_hd__fill_2
XFILLER_0_24_212 VGND VGND VPWR VPWR sky130_fd_sc_hd__fill_2
Xinput25 S_AXI_ARADDR[31] VGND VGND VPWR VPWR net25 sky130_fd_sc_hd__buf_1
Xinput36 S_AXI_AWADDR[10] VGND VGND VPWR VPWR net36 sky130_fd_sc_hd__buf_1
X_2410_ _0577_ _0596_ _0597_ _0598_ VGND VGND VPWR VPWR _0599_ sky130_fd_sc_hd__a31o_2
Xinput47 S_AXI_AWADDR[20] VGND VGND VPWR VPWR net47 sky130_fd_sc_hd__buf_1
Xinput69 S_AXI_RREADY VGND VGND VPWR VPWR net69 sky130_fd_sc_hd__buf_2
Xinput58 S_AXI_AWADDR[30] VGND VGND VPWR VPWR net58 sky130_fd_sc_hd__buf_1
X_3390_ TX.baud_counter\[29\] TX.baud_counter\[28\] _1429_ VGND VGND VPWR VPWR _1434_
+ sky130_fd_sc_hd__and3_1
X_2341_ _0518_ _0523_ _0526_ _0529_ VGND VGND VPWR VPWR _0530_ sky130_fd_sc_hd__a31oi_2
X_2272_ net184 net69 VGND VGND VPWR VPWR _0479_ sky130_fd_sc_hd__nand2_1
X_1987_ net161 VGND VGND VPWR VPWR _1677_ sky130_fd_sc_hd__buf_2
X_3657_ clknet_leaf_5_S_AXI_ACLK _0222_ VGND VGND VPWR VPWR RX.uart_cpb\[15\] sky130_fd_sc_hd__dfxtp_2
XFILLER_0_15_267 VGND VGND VPWR VPWR sky130_fd_sc_hd__fill_1
XFILLER_0_15_278 VGND VGND VPWR VPWR sky130_fd_sc_hd__fill_2
X_2539_ _0706_ _0716_ VGND VGND VPWR VPWR _0728_ sky130_fd_sc_hd__and2_1
X_2608_ _0676_ _0793_ _0794_ VGND VGND VPWR VPWR _0797_ sky130_fd_sc_hd__a21o_1
X_3588_ clknet_leaf_21_S_AXI_ACLK _0153_ net148 VGND VGND VPWR VPWR RX.baud_cnt\[21\]
+ sky130_fd_sc_hd__dfrtp_4
X_1910_ uart_rdr\[24\] _1513_ _1590_ VGND VGND VPWR VPWR _1620_ sky130_fd_sc_hd__a21bo_1
X_2890_ RX.baud_cnt\[4\] _0820_ VGND VGND VPWR VPWR _1067_ sky130_fd_sc_hd__nand2_1
X_1772_ net26 _1503_ _1505_ VGND VGND VPWR VPWR _1506_ sky130_fd_sc_hd__and3_2
X_1841_ _1534_ net199 _1561_ _1565_ VGND VGND VPWR VPWR _0017_ sky130_fd_sc_hd__o211a_1
X_3511_ clknet_leaf_15_S_AXI_ACLK _0076_ VGND VGND VPWR VPWR RX.uart_cpb\[4\] sky130_fd_sc_hd__dfxtp_1
X_3442_ clknet_leaf_5_S_AXI_ACLK _0007_ VGND VGND VPWR VPWR TX.uart_tdr\[31\] sky130_fd_sc_hd__dfxtp_1
X_3373_ _1381_ _1421_ VGND VGND VPWR VPWR _1422_ sky130_fd_sc_hd__nor2_1
X_2324_ _0511_ _0512_ VGND VGND VPWR VPWR _0513_ sky130_fd_sc_hd__nand2_1
X_2186_ RX.uart_cpb\[12\] _0338_ RX.uart_cpb\[13\] VGND VGND VPWR VPWR _0397_ sky130_fd_sc_hd__o21a_1
X_2255_ _0460_ _0454_ VGND VGND VPWR VPWR _0466_ sky130_fd_sc_hd__and2_1
XFILLER_0_47_101 VGND VGND VPWR VPWR sky130_fd_sc_hd__decap_3
XFILLER_0_7_220 VGND VGND VPWR VPWR sky130_fd_sc_hd__fill_1
XFILLER_0_7_231 VGND VGND VPWR VPWR sky130_fd_sc_hd__fill_2
X_3709_ clknet_leaf_6_S_AXI_ACLK _0274_ VGND VGND VPWR VPWR RX.uart_stp\[8\] sky130_fd_sc_hd__dfxtp_1
XFILLER_0_11_281 VGND VGND VPWR VPWR sky130_fd_sc_hd__fill_2
XFILLER_0_38_123 VGND VGND VPWR VPWR sky130_fd_sc_hd__fill_2
XFILLER_0_53_137 VGND VGND VPWR VPWR sky130_fd_sc_hd__fill_2
XTAP_207 VGND VPWR sky130_fd_sc_hd__tapvpwrvgnd_1
XTAP_218 VGND VPWR sky130_fd_sc_hd__tapvpwrvgnd_1
XTAP_229 VGND VPWR sky130_fd_sc_hd__tapvpwrvgnd_1
Xhold3 net124 VGND VGND VPWR VPWR net170 sky130_fd_sc_hd__dlygate4sd3_1
X_2040_ _1700_ _1713_ VGND VGND VPWR VPWR _1714_ sky130_fd_sc_hd__and2_1
XFILLER_0_44_137 VGND VGND VPWR VPWR sky130_fd_sc_hd__decap_3
XFILLER_0_29_167 VGND VGND VPWR VPWR sky130_fd_sc_hd__fill_1
XFILLER_0_29_101 VGND VGND VPWR VPWR sky130_fd_sc_hd__decap_4
X_2942_ _0959_ _0866_ _1118_ VGND VGND VPWR VPWR _1119_ sky130_fd_sc_hd__o21ai_1
X_2873_ _0996_ _1009_ _1013_ _1049_ VGND VGND VPWR VPWR _1050_ sky130_fd_sc_hd__o22a_1
X_1755_ net91 _1482_ _1491_ _1486_ VGND VGND VPWR VPWR _0005_ sky130_fd_sc_hd__o211a_1
XFILLER_0_4_212 VGND VGND VPWR VPWR sky130_fd_sc_hd__fill_1
X_1824_ RX.uart_cpb\[6\] _1536_ _1549_ _1551_ VGND VGND VPWR VPWR _1552_ sky130_fd_sc_hd__a211o_1
XFILLER_0_20_83 VGND VGND VPWR VPWR sky130_fd_sc_hd__fill_1
X_2307_ net267 _0497_ VGND VGND VPWR VPWR _0501_ sky130_fd_sc_hd__or2_1
X_3425_ net248 _1451_ VGND VGND VPWR VPWR _1455_ sky130_fd_sc_hd__or2_1
X_2238_ RX.uart_cpb\[31\] VGND VGND VPWR VPWR _0449_ sky130_fd_sc_hd__inv_2
XFILLER_0_31_3 VGND VGND VPWR VPWR sky130_fd_sc_hd__fill_1
XFILLER_0_29_81 VGND VGND VPWR VPWR sky130_fd_sc_hd__fill_2
X_3356_ TX.baud_counter\[19\] TX.baud_counter\[18\] _1401_ TX.baud_counter\[20\] VGND
+ VGND VPWR VPWR _1409_ sky130_fd_sc_hd__a31o_1
X_3287_ _1353_ _1357_ VGND VGND VPWR VPWR _1358_ sky130_fd_sc_hd__nor2_1
X_2169_ _0374_ _0377_ _0378_ TX.baud_counter\[8\] _0379_ VGND VGND VPWR VPWR _0380_
+ sky130_fd_sc_hd__o221a_1
XFILLER_0_43_192 VGND VGND VPWR VPWR sky130_fd_sc_hd__decap_3
XFILLER_0_41_27 VGND VGND VPWR VPWR sky130_fd_sc_hd__fill_1
XFILLER_0_26_115 VGND VGND VPWR VPWR sky130_fd_sc_hd__fill_2
XFILLER_0_1_259 VGND VGND VPWR VPWR sky130_fd_sc_hd__fill_2
X_3141_ _1269_ VGND VGND VPWR VPWR _0178_ sky130_fd_sc_hd__clkbuf_1
X_3210_ _1000_ _1305_ VGND VGND VPWR VPWR _1308_ sky130_fd_sc_hd__nand2_1
X_2023_ _1702_ VGND VGND VPWR VPWR _0062_ sky130_fd_sc_hd__clkbuf_1
X_3072_ _1194_ _1220_ _1222_ _1186_ RX.baud_cnt\[24\] VGND VGND VPWR VPWR _0156_ sky130_fd_sc_hd__a32o_1
X_1807_ _1512_ VGND VGND VPWR VPWR _1538_ sky130_fd_sc_hd__buf_2
XFILLER_0_31_82 VGND VGND VPWR VPWR sky130_fd_sc_hd__decap_3
X_2856_ RX.baud_cnt\[9\] VGND VGND VPWR VPWR _1033_ sky130_fd_sc_hd__inv_2
X_2925_ _1096_ _1099_ _1100_ _1101_ VGND VGND VPWR VPWR _1102_ sky130_fd_sc_hd__or4b_1
X_1738_ net109 net105 VGND VGND VPWR VPWR _1480_ sky130_fd_sc_hd__nand2_2
X_2787_ RX.baud_cnt\[29\] _0458_ _0961_ _0962_ _0963_ VGND VGND VPWR VPWR _0964_ sky130_fd_sc_hd__o221a_1
XFILLER_0_0_281 VGND VGND VPWR VPWR sky130_fd_sc_hd__decap_3
X_3408_ TX.data_latch_next\[4\] net323 _1440_ VGND VGND VPWR VPWR _1445_ sky130_fd_sc_hd__mux2_1
X_3339_ _1381_ _1396_ VGND VGND VPWR VPWR _1397_ sky130_fd_sc_hd__nor2_1
XFILLER_0_36_38 VGND VGND VPWR VPWR sky130_fd_sc_hd__fill_1
X_2710_ net225 _0884_ VGND VGND VPWR VPWR _0891_ sky130_fd_sc_hd__or2_1
X_3690_ clknet_leaf_20_S_AXI_ACLK _0255_ net148 VGND VGND VPWR VPWR TX.baud_counter\[21\]
+ sky130_fd_sc_hd__dfrtp_4
X_2572_ _0577_ _0759_ _0760_ VGND VGND VPWR VPWR _0761_ sky130_fd_sc_hd__a21o_1
X_2641_ TX.baud_counter\[6\] _0826_ _0829_ TX.baud_counter\[7\] VGND VGND VPWR VPWR
+ _0830_ sky130_fd_sc_hd__a22o_1
X_3124_ net330 net107 _1259_ VGND VGND VPWR VPWR _1260_ sky130_fd_sc_hd__mux2_1
X_3055_ _0904_ _1207_ RX.baud_cnt\[20\] VGND VGND VPWR VPWR _1210_ sky130_fd_sc_hd__a21o_1
X_2006_ RX.done_reg VGND VGND VPWR VPWR _1690_ sky130_fd_sc_hd__buf_2
X_2839_ RX.baud_cnt\[4\] VGND VGND VPWR VPWR _1016_ sky130_fd_sc_hd__inv_2
X_2908_ _0910_ _0805_ _1084_ VGND VGND VPWR VPWR _1085_ sky130_fd_sc_hd__o21a_1
XTAP_390 VGND VPWR sky130_fd_sc_hd__tapvpwrvgnd_1
XPHY_30 VGND VGND VPWR VPWR sky130_fd_sc_hd__decap_3
XPHY_96 VGND VGND VPWR VPWR sky130_fd_sc_hd__decap_3
XPHY_85 VGND VGND VPWR VPWR sky130_fd_sc_hd__decap_3
XPHY_74 VGND VGND VPWR VPWR sky130_fd_sc_hd__decap_3
XPHY_63 VGND VGND VPWR VPWR sky130_fd_sc_hd__decap_3
XPHY_52 VGND VGND VPWR VPWR sky130_fd_sc_hd__decap_3
XPHY_41 VGND VGND VPWR VPWR sky130_fd_sc_hd__decap_3
XFILLER_0_2_321 VPWR VGND VPWR VGND sky130_ef_sc_hd__decap_12
X_2624_ _0623_ _0812_ VGND VGND VPWR VPWR _0813_ sky130_fd_sc_hd__xor2_1
X_3673_ clknet_leaf_19_S_AXI_ACLK _0238_ net151 VGND VGND VPWR VPWR TX.baud_counter\[4\]
+ sky130_fd_sc_hd__dfrtp_4
Xoutput113 net113 VGND VGND VPWR VPWR S_AXI_RDATA[11] sky130_fd_sc_hd__clkbuf_4
Xoutput124 net124 VGND VGND VPWR VPWR S_AXI_RDATA[21] sky130_fd_sc_hd__clkbuf_4
Xoutput135 net135 VGND VGND VPWR VPWR S_AXI_RDATA[31] sky130_fd_sc_hd__clkbuf_4
X_2555_ _0741_ _0742_ VGND VGND VPWR VPWR _0744_ sky130_fd_sc_hd__or2_1
X_2486_ _0599_ _0660_ _0669_ _0674_ VGND VGND VPWR VPWR _0675_ sky130_fd_sc_hd__and4_1
X_3107_ _1150_ RX.bit_idx\[2\] _1155_ _1242_ VGND VGND VPWR VPWR _1247_ sky130_fd_sc_hd__or4_1
X_3038_ _1176_ _1198_ _1152_ VGND VGND VPWR VPWR _1199_ sky130_fd_sc_hd__o21bai_1
XFILLER_0_56_327 VPWR VGND VPWR VGND sky130_ef_sc_hd__decap_12
Xinput59 S_AXI_AWADDR[31] VGND VGND VPWR VPWR net59 sky130_fd_sc_hd__dlymetal6s2s_1
Xinput48 S_AXI_AWADDR[21] VGND VGND VPWR VPWR net48 sky130_fd_sc_hd__clkbuf_1
Xinput37 S_AXI_AWADDR[11] VGND VGND VPWR VPWR net37 sky130_fd_sc_hd__buf_1
Xinput26 S_AXI_ARADDR[3] VGND VGND VPWR VPWR net26 sky130_fd_sc_hd__buf_2
Xinput15 S_AXI_ARADDR[22] VGND VGND VPWR VPWR net15 sky130_fd_sc_hd__buf_1
X_2340_ _0335_ _0516_ _0517_ _0527_ _0528_ VGND VGND VPWR VPWR _0529_ sky130_fd_sc_hd__a41o_1
X_2271_ _0478_ VGND VGND VPWR VPWR _0099_ sky130_fd_sc_hd__clkbuf_1
X_1986_ _1676_ VGND VGND VPWR VPWR _0051_ sky130_fd_sc_hd__clkbuf_1
XFILLER_0_23_61 VGND VGND VPWR VPWR sky130_fd_sc_hd__fill_1
X_3656_ clknet_leaf_5_S_AXI_ACLK _0221_ VGND VGND VPWR VPWR RX.uart_cpb\[14\] sky130_fd_sc_hd__dfxtp_4
X_2607_ _0676_ _0688_ _0795_ _0683_ VGND VGND VPWR VPWR _0796_ sky130_fd_sc_hd__a22oi_4
X_3587_ clknet_leaf_21_S_AXI_ACLK _0152_ net149 VGND VGND VPWR VPWR RX.baud_cnt\[20\]
+ sky130_fd_sc_hd__dfrtp_4
X_2538_ _0724_ _0723_ _0709_ _0710_ _0707_ VGND VGND VPWR VPWR _0727_ sky130_fd_sc_hd__a221o_1
X_2469_ RX.uart_cpb\[10\] _1525_ _0581_ RX.uart_cpb\[11\] VGND VGND VPWR VPWR _0658_
+ sky130_fd_sc_hd__a22o_1
X_1840_ _1562_ _1536_ _1563_ _1564_ VGND VGND VPWR VPWR _1565_ sky130_fd_sc_hd__a211o_1
X_1771_ net12 net1 net23 _1504_ VGND VGND VPWR VPWR _1505_ sky130_fd_sc_hd__and4bb_1
X_3441_ clknet_leaf_3_S_AXI_ACLK _0006_ VGND VGND VPWR VPWR TX.uart_tdr\[30\] sky130_fd_sc_hd__dfxtp_1
X_3510_ clknet_leaf_15_S_AXI_ACLK _0075_ VGND VGND VPWR VPWR RX.uart_cpb\[3\] sky130_fd_sc_hd__dfxtp_1
XFILLER_0_8_38 VGND VGND VPWR VPWR sky130_fd_sc_hd__fill_1
XFILLER_0_8_49 VGND VGND VPWR VPWR sky130_fd_sc_hd__fill_1
X_2323_ RX.uart_cpb\[12\] RX.uart_cpb\[11\] VGND VGND VPWR VPWR _0512_ sky130_fd_sc_hd__xor2_1
X_3372_ TX.baud_counter\[24\] _1418_ VGND VGND VPWR VPWR _1421_ sky130_fd_sc_hd__and2_2
X_2254_ _0454_ VGND VGND VPWR VPWR _0465_ sky130_fd_sc_hd__inv_2
XFILLER_0_26_6 VGND VGND VPWR VPWR sky130_fd_sc_hd__decap_3
X_2185_ _0338_ _0339_ VGND VGND VPWR VPWR _0396_ sky130_fd_sc_hd__nor2_2
XFILLER_0_18_83 VGND VGND VPWR VPWR sky130_fd_sc_hd__fill_1
XFILLER_0_55_190 VGND VGND VPWR VPWR sky130_fd_sc_hd__fill_1
X_1969_ _1664_ VGND VGND VPWR VPWR _0046_ sky130_fd_sc_hd__buf_1
X_3639_ clknet_leaf_4_S_AXI_ACLK _0204_ VGND VGND VPWR VPWR RX.uart_cpb\[29\] sky130_fd_sc_hd__dfxtp_2
X_3708_ clknet_leaf_13_S_AXI_ACLK _0273_ net157 VGND VGND VPWR VPWR TX.data_latch\[7\]
+ sky130_fd_sc_hd__dfrtp_1
Xhold4 net129 VGND VGND VPWR VPWR net171 sky130_fd_sc_hd__dlygate4sd3_1
XTAP_208 VGND VPWR sky130_fd_sc_hd__tapvpwrvgnd_1
XTAP_219 VGND VPWR sky130_fd_sc_hd__tapvpwrvgnd_1
X_1823_ uart_rdr\[6\] _1538_ _1550_ VGND VGND VPWR VPWR _1551_ sky130_fd_sc_hd__a21bo_1
X_2941_ RX.baud_cnt\[26\] _0861_ VGND VGND VPWR VPWR _1118_ sky130_fd_sc_hd__or2_1
X_2872_ _1028_ _1043_ _1044_ _1048_ _1036_ VGND VGND VPWR VPWR _1049_ sky130_fd_sc_hd__o32a_1
X_1754_ net232 _1483_ VGND VGND VPWR VPWR _1491_ sky130_fd_sc_hd__or2_1
X_3424_ net71 _1450_ _1454_ _1336_ VGND VGND VPWR VPWR _0276_ sky130_fd_sc_hd__o211a_1
XFILLER_0_40_355 VGND VGND VPWR VPWR sky130_fd_sc_hd__decap_3
X_2306_ net71 _0496_ _0500_ _0487_ VGND VGND VPWR VPWR _0112_ sky130_fd_sc_hd__o211a_1
X_2237_ _1639_ _0447_ VGND VGND VPWR VPWR _0448_ sky130_fd_sc_hd__nor2_1
XFILLER_0_24_3 VGND VGND VPWR VPWR sky130_fd_sc_hd__fill_2
X_3355_ TX.baud_counter\[19\] _1355_ _1350_ _1408_ VGND VGND VPWR VPWR _0253_ sky130_fd_sc_hd__a22o_1
X_3286_ TX.baud_counter\[0\] TX.baud_counter\[1\] TX.baud_counter\[2\] VGND VGND VPWR
+ VPWR _1357_ sky130_fd_sc_hd__and3_1
X_2168_ TX.baud_counter\[7\] _0376_ VGND VGND VPWR VPWR _0379_ sky130_fd_sc_hd__or2_1
X_2099_ net98 _0309_ _0319_ _0296_ VGND VGND VPWR VPWR _0086_ sky130_fd_sc_hd__o211a_1
XFILLER_0_16_363 VGND VGND VPWR VPWR sky130_fd_sc_hd__fill_1
XFILLER_0_26_105 VGND VGND VPWR VPWR sky130_fd_sc_hd__fill_1
X_3140_ net295 VGND VGND VPWR VPWR _1269_ sky130_fd_sc_hd__clkbuf_1
X_3071_ _0974_ _1221_ VGND VGND VPWR VPWR _1222_ sky130_fd_sc_hd__nor2_1
X_2022_ _1700_ _1701_ VGND VGND VPWR VPWR _1702_ sky130_fd_sc_hd__and2_1
XFILLER_0_57_296 VGND VGND VPWR VPWR sky130_fd_sc_hd__fill_1
X_1806_ TX.data_latch_next\[3\] _1507_ _1509_ RX.uart_stp\[3\] VGND VGND VPWR VPWR
+ _1537_ sky130_fd_sc_hd__a22o_1
X_2924_ _0904_ _0790_ _0796_ RX.baud_cnt\[18\] VGND VGND VPWR VPWR _1101_ sky130_fd_sc_hd__o22a_1
X_2855_ RX.uart_cpb\[12\] _1030_ _1031_ RX.uart_cpb\[11\] VGND VGND VPWR VPWR _1032_
+ sky130_fd_sc_hd__a22o_1
X_2786_ RX.baud_cnt\[28\] _0456_ VGND VGND VPWR VPWR _0963_ sky130_fd_sc_hd__or2_1
X_3407_ net304 VGND VGND VPWR VPWR _0269_ sky130_fd_sc_hd__clkbuf_1
X_1737_ _1478_ VGND VGND VPWR VPWR _1479_ sky130_fd_sc_hd__clkbuf_4
X_3338_ TX.baud_counter\[15\] _1393_ VGND VGND VPWR VPWR _1396_ sky130_fd_sc_hd__and2_1
X_3269_ TX.state\[1\] TX.state\[0\] VGND VGND VPWR VPWR _1345_ sky130_fd_sc_hd__and2_1
XFILLER_0_31_163 VGND VGND VPWR VPWR sky130_fd_sc_hd__fill_2
Xclkbuf_leaf_15_S_AXI_ACLK clknet_1_1__leaf_S_AXI_ACLK VGND VGND VPWR VPWR clknet_leaf_15_S_AXI_ACLK
+ sky130_fd_sc_hd__clkbuf_16
X_2640_ _0640_ _0644_ VGND VGND VPWR VPWR _0829_ sky130_fd_sc_hd__xor2_2
X_2571_ RX.uart_cpb\[29\] _1526_ _0582_ _1639_ VGND VGND VPWR VPWR _0760_ sky130_fd_sc_hd__a22o_1
X_2005_ _1689_ VGND VGND VPWR VPWR _0057_ sky130_fd_sc_hd__clkbuf_1
X_3123_ _1242_ _1258_ VGND VGND VPWR VPWR _1259_ sky130_fd_sc_hd__nor2_1
X_3054_ _1194_ _1207_ _1209_ _1208_ _0904_ VGND VGND VPWR VPWR _0151_ sky130_fd_sc_hd__a32o_1
XFILLER_0_9_113 VGND VGND VPWR VPWR sky130_fd_sc_hd__fill_2
X_2907_ RX.baud_cnt\[12\] _0803_ VGND VGND VPWR VPWR _1084_ sky130_fd_sc_hd__or2_1
X_2838_ _1553_ _1014_ RX.baud_cnt\[5\] _0303_ VGND VGND VPWR VPWR _1015_ sky130_fd_sc_hd__a2bb2o_1
X_2769_ _0940_ _0941_ _0944_ _0945_ VGND VGND VPWR VPWR _0946_ sky130_fd_sc_hd__nor4_1
XTAP_391 VGND VPWR sky130_fd_sc_hd__tapvpwrvgnd_1
XTAP_380 VGND VPWR sky130_fd_sc_hd__tapvpwrvgnd_1
XPHY_64 VGND VGND VPWR VPWR sky130_fd_sc_hd__decap_3
XPHY_53 VGND VGND VPWR VPWR sky130_fd_sc_hd__decap_3
XPHY_20 VGND VGND VPWR VPWR sky130_fd_sc_hd__decap_3
XPHY_31 VGND VGND VPWR VPWR sky130_fd_sc_hd__decap_3
XPHY_42 VGND VGND VPWR VPWR sky130_fd_sc_hd__decap_3
XFILLER_0_51_225 VGND VGND VPWR VPWR sky130_fd_sc_hd__decap_3
XPHY_97 VGND VGND VPWR VPWR sky130_fd_sc_hd__decap_3
XPHY_86 VGND VGND VPWR VPWR sky130_fd_sc_hd__decap_3
XPHY_75 VGND VGND VPWR VPWR sky130_fd_sc_hd__decap_3
XFILLER_0_2_29 VPWR VGND VPWR VGND sky130_ef_sc_hd__decap_12
Xoutput125 net125 VGND VGND VPWR VPWR S_AXI_RDATA[22] sky130_fd_sc_hd__clkbuf_4
XFILLER_0_42_225 VGND VGND VPWR VPWR sky130_fd_sc_hd__fill_2
Xoutput114 net114 VGND VGND VPWR VPWR S_AXI_RDATA[12] sky130_fd_sc_hd__clkbuf_4
X_2554_ _0741_ _0742_ VGND VGND VPWR VPWR _0743_ sky130_fd_sc_hd__and2_1
X_3672_ clknet_leaf_19_S_AXI_ACLK _0237_ net151 VGND VGND VPWR VPWR TX.baud_counter\[3\]
+ sky130_fd_sc_hd__dfrtp_2
XFILLER_0_2_333 VPWR VGND VPWR VGND sky130_ef_sc_hd__decap_12
XFILLER_0_2_300 VGND VGND VPWR VPWR sky130_fd_sc_hd__decap_8
X_2623_ _0621_ _0622_ VGND VGND VPWR VPWR _0812_ sky130_fd_sc_hd__nor2_1
XFILLER_0_12_96 VGND VGND VPWR VPWR sky130_fd_sc_hd__fill_2
Xoutput136 net136 VGND VGND VPWR VPWR S_AXI_RDATA[3] sky130_fd_sc_hd__clkbuf_4
X_2485_ _0670_ _0312_ _0671_ _0672_ _0673_ VGND VGND VPWR VPWR _0674_ sky130_fd_sc_hd__o221a_2
X_3106_ _1241_ _1245_ _1246_ VGND VGND VPWR VPWR _0166_ sky130_fd_sc_hd__o21a_1
X_3037_ RX.baud_cnt\[14\] _0910_ _1192_ VGND VGND VPWR VPWR _1198_ sky130_fd_sc_hd__and3_1
XFILLER_0_18_222 VGND VGND VPWR VPWR sky130_fd_sc_hd__fill_2
XFILLER_0_56_339 VPWR VGND VPWR VGND sky130_ef_sc_hd__decap_12
XFILLER_0_56_306 VGND VGND VPWR VPWR sky130_fd_sc_hd__fill_2
Xinput49 S_AXI_AWADDR[22] VGND VGND VPWR VPWR net49 sky130_fd_sc_hd__clkbuf_1
Xinput27 S_AXI_ARADDR[4] VGND VGND VPWR VPWR net27 sky130_fd_sc_hd__clkbuf_2
Xinput38 S_AXI_AWADDR[12] VGND VGND VPWR VPWR net38 sky130_fd_sc_hd__buf_1
Xinput16 S_AXI_ARADDR[23] VGND VGND VPWR VPWR net16 sky130_fd_sc_hd__clkbuf_2
Xclkbuf_leaf_5_S_AXI_ACLK clknet_1_1__leaf_S_AXI_ACLK VGND VGND VPWR VPWR clknet_leaf_5_S_AXI_ACLK
+ sky130_fd_sc_hd__clkbuf_16
X_2270_ net109 _1485_ net67 net106 VGND VGND VPWR VPWR _0478_ sky130_fd_sc_hd__and4b_1
X_1985_ _1654_ _1675_ VGND VGND VPWR VPWR _1676_ sky130_fd_sc_hd__and2_1
XFILLER_0_15_225 VGND VGND VPWR VPWR sky130_fd_sc_hd__decap_4
XFILLER_0_23_73 VGND VGND VPWR VPWR sky130_fd_sc_hd__decap_6
X_3655_ clknet_leaf_5_S_AXI_ACLK _0220_ VGND VGND VPWR VPWR RX.uart_cpb\[13\] sky130_fd_sc_hd__dfxtp_2
X_2537_ _0442_ _0725_ VGND VGND VPWR VPWR _0726_ sky130_fd_sc_hd__nand2_1
X_2606_ _0676_ _0793_ _0794_ VGND VGND VPWR VPWR _0795_ sky130_fd_sc_hd__nand3_2
X_3586_ clknet_leaf_21_S_AXI_ACLK _0151_ net149 VGND VGND VPWR VPWR RX.baud_cnt\[19\]
+ sky130_fd_sc_hd__dfrtp_1
X_2468_ _0656_ _0512_ _0651_ VGND VGND VPWR VPWR _0657_ sky130_fd_sc_hd__or3b_1
X_2399_ _0312_ RX.uart_stp\[0\] VGND VGND VPWR VPWR _0588_ sky130_fd_sc_hd__nand2_1
XFILLER_0_53_309 VPWR VGND VPWR VGND sky130_ef_sc_hd__decap_12
XFILLER_0_28_29 VGND VGND VPWR VPWR sky130_fd_sc_hd__fill_1
Xfanout160 net162 VGND VGND VPWR VPWR net160 sky130_fd_sc_hd__clkbuf_4
X_1770_ net28 net27 net30 net29 VGND VGND VPWR VPWR _1504_ sky130_fd_sc_hd__nor4_1
X_3440_ clknet_leaf_3_S_AXI_ACLK _0005_ VGND VGND VPWR VPWR TX.uart_tdr\[29\] sky130_fd_sc_hd__dfxtp_1
X_3371_ TX.baud_counter\[24\] _1418_ VGND VGND VPWR VPWR _1420_ sky130_fd_sc_hd__or2_1
X_2322_ _0337_ _0510_ VGND VGND VPWR VPWR _0511_ sky130_fd_sc_hd__and2_1
X_2184_ _0388_ _0391_ _0393_ TX.baud_counter\[12\] _0394_ VGND VGND VPWR VPWR _0395_
+ sky130_fd_sc_hd__o221a_1
X_2253_ _0454_ _0459_ _0461_ _0463_ VGND VGND VPWR VPWR _0464_ sky130_fd_sc_hd__and4bb_1
XFILLER_0_19_6 VGND VGND VPWR VPWR sky130_fd_sc_hd__fill_1
X_1899_ RX.uart_cpb\[21\] _1578_ _1610_ _1611_ VGND VGND VPWR VPWR _1612_ sky130_fd_sc_hd__a211o_1
X_1968_ _1654_ _1663_ VGND VGND VPWR VPWR _1664_ sky130_fd_sc_hd__and2_1
XFILLER_0_7_255 VGND VGND VPWR VPWR sky130_fd_sc_hd__decap_4
XFILLER_0_7_288 VGND VGND VPWR VPWR sky130_fd_sc_hd__fill_2
X_3707_ clknet_leaf_14_S_AXI_ACLK _0272_ net157 VGND VGND VPWR VPWR TX.data_latch\[6\]
+ sky130_fd_sc_hd__dfrtp_1
X_3638_ clknet_leaf_4_S_AXI_ACLK _0203_ VGND VGND VPWR VPWR RX.uart_cpb\[28\] sky130_fd_sc_hd__dfxtp_2
X_3569_ clknet_leaf_16_S_AXI_ACLK _0134_ net158 VGND VGND VPWR VPWR RX.baud_cnt\[2\]
+ sky130_fd_sc_hd__dfrtp_4
XFILLER_0_53_128 VGND VGND VPWR VPWR sky130_fd_sc_hd__fill_1
Xhold5 net119 VGND VGND VPWR VPWR net172 sky130_fd_sc_hd__dlygate4sd3_1
XTAP_209 VGND VPWR sky130_fd_sc_hd__tapvpwrvgnd_1
X_2940_ _1095_ _1111_ _1114_ _1096_ _1116_ VGND VGND VPWR VPWR _1117_ sky130_fd_sc_hd__o221a_1
X_1753_ net90 _1482_ _1490_ _1486_ VGND VGND VPWR VPWR _0004_ sky130_fd_sc_hd__o211a_1
X_1822_ net108 VGND VGND VPWR VPWR _1550_ sky130_fd_sc_hd__buf_2
XFILLER_0_4_203 VGND VGND VPWR VPWR sky130_fd_sc_hd__fill_2
X_2871_ _1029_ _1047_ _1039_ VGND VGND VPWR VPWR _1048_ sky130_fd_sc_hd__o21a_1
Xmax_cap146 net331 VGND VGND VPWR VPWR net146 sky130_fd_sc_hd__buf_1
X_3423_ net226 _1451_ VGND VGND VPWR VPWR _1454_ sky130_fd_sc_hd__or2_1
X_3354_ TX.baud_counter\[19\] _1405_ _1407_ VGND VGND VPWR VPWR _1408_ sky130_fd_sc_hd__o21a_1
XFILLER_0_20_85 VGND VGND VPWR VPWR sky130_fd_sc_hd__fill_2
X_2305_ net265 _0497_ VGND VGND VPWR VPWR _0500_ sky130_fd_sc_hd__or2_1
X_2236_ RX.uart_cpb\[29\] RX.uart_cpb\[28\] _0443_ VGND VGND VPWR VPWR _0447_ sky130_fd_sc_hd__or3_1
X_3285_ TX.baud_counter\[0\] TX.baud_counter\[1\] TX.baud_counter\[2\] VGND VGND VPWR
+ VPWR _1356_ sky130_fd_sc_hd__a21o_1
X_2167_ _1557_ _0336_ VGND VGND VPWR VPWR _0378_ sky130_fd_sc_hd__xor2_2
XFILLER_0_17_3 VGND VGND VPWR VPWR sky130_fd_sc_hd__fill_1
X_2098_ net254 _0310_ VGND VGND VPWR VPWR _0319_ sky130_fd_sc_hd__or2_1
XFILLER_0_43_183 VGND VGND VPWR VPWR sky130_fd_sc_hd__fill_2
XFILLER_0_16_342 VGND VGND VPWR VPWR sky130_fd_sc_hd__fill_1
XFILLER_0_5_29 VGND VGND VPWR VPWR sky130_fd_sc_hd__fill_1
X_2021_ _1690_ RX.rx_shifter\[22\] _1695_ uart_rdr\[22\] VGND VGND VPWR VPWR _1701_
+ sky130_fd_sc_hd__a22o_1
X_3070_ RX.baud_cnt\[24\] _0895_ _1217_ VGND VGND VPWR VPWR _1221_ sky130_fd_sc_hd__and3_1
X_2923_ RX.baud_cnt\[18\] _0796_ _0798_ _0902_ VGND VGND VPWR VPWR _1100_ sky130_fd_sc_hd__a22o_1
X_1805_ _1520_ VGND VGND VPWR VPWR _1536_ sky130_fd_sc_hd__clkbuf_4
XFILLER_0_31_95 VGND VGND VPWR VPWR sky130_fd_sc_hd__decap_4
X_1736_ _1466_ _1474_ _1477_ VGND VGND VPWR VPWR _1478_ sky130_fd_sc_hd__or3_1
X_2785_ RX.baud_cnt\[28\] _0456_ _0444_ _0959_ VGND VGND VPWR VPWR _0962_ sky130_fd_sc_hd__a22o_1
X_2854_ RX.baud_cnt\[10\] VGND VGND VPWR VPWR _1031_ sky130_fd_sc_hd__inv_2
X_3406_ net303 TX.data_latch\[3\] _1440_ VGND VGND VPWR VPWR _1444_ sky130_fd_sc_hd__mux2_1
X_3337_ TX.baud_counter\[15\] _1393_ VGND VGND VPWR VPWR _1395_ sky130_fd_sc_hd__or2_1
X_3199_ net93 _1292_ _1300_ _0890_ VGND VGND VPWR VPWR _0205_ sky130_fd_sc_hd__o211a_1
X_2219_ _0428_ _0429_ VGND VGND VPWR VPWR _0430_ sky130_fd_sc_hd__xnor2_2
X_3268_ _1339_ _1340_ _1343_ VGND VGND VPWR VPWR _1344_ sky130_fd_sc_hd__o21ba_1
XFILLER_0_36_29 VGND VGND VPWR VPWR sky130_fd_sc_hd__fill_2
XFILLER_0_39_231 VGND VGND VPWR VPWR sky130_fd_sc_hd__fill_1
X_2570_ _0757_ _0758_ VGND VGND VPWR VPWR _0759_ sky130_fd_sc_hd__xnor2_1
X_3122_ RX.bit_idx\[2\] _1249_ VGND VGND VPWR VPWR _1258_ sky130_fd_sc_hd__nand2_1
XFILLER_0_22_186 VGND VGND VPWR VPWR sky130_fd_sc_hd__fill_2
X_2004_ _1677_ _1688_ VGND VGND VPWR VPWR _1689_ sky130_fd_sc_hd__and2_1
XFILLER_0_26_62 VGND VGND VPWR VPWR sky130_fd_sc_hd__fill_2
X_3053_ _0904_ _1160_ VGND VGND VPWR VPWR _1209_ sky130_fd_sc_hd__nor2_1
XFILLER_0_45_256 VGND VGND VPWR VPWR sky130_fd_sc_hd__fill_1
XFILLER_0_45_223 VGND VGND VPWR VPWR sky130_fd_sc_hd__fill_1
XFILLER_0_42_83 VGND VGND VPWR VPWR sky130_fd_sc_hd__fill_1
X_2906_ RX.baud_cnt\[8\] _0832_ _1079_ _1080_ _1082_ VGND VGND VPWR VPWR _1083_ sky130_fd_sc_hd__a2111o_1
X_2699_ net277 _0884_ VGND VGND VPWR VPWR _0885_ sky130_fd_sc_hd__or2_1
XFILLER_0_5_342 VGND VGND VPWR VPWR sky130_fd_sc_hd__decap_3
X_2837_ RX.baud_cnt\[6\] VGND VGND VPWR VPWR _1014_ sky130_fd_sc_hd__inv_2
XFILLER_0_13_142 VGND VGND VPWR VPWR sky130_fd_sc_hd__fill_2
X_2768_ RX.baud_cnt\[23\] _0349_ _0898_ _0900_ _0905_ VGND VGND VPWR VPWR _0945_ sky130_fd_sc_hd__a2111o_1
X_1719_ TX.data_latch\[4\] TX.data_latch\[5\] TX.data_latch\[6\] TX.data_latch\[7\]
+ TX.bit_index\[0\] TX.bit_index\[1\] VGND VGND VPWR VPWR _1462_ sky130_fd_sc_hd__mux4_1
XTAP_392 VGND VPWR sky130_fd_sc_hd__tapvpwrvgnd_1
XTAP_381 VGND VPWR sky130_fd_sc_hd__tapvpwrvgnd_1
XTAP_370 VGND VPWR sky130_fd_sc_hd__tapvpwrvgnd_1
XPHY_98 VGND VGND VPWR VPWR sky130_fd_sc_hd__decap_3
XPHY_87 VGND VGND VPWR VPWR sky130_fd_sc_hd__decap_3
XPHY_76 VGND VGND VPWR VPWR sky130_fd_sc_hd__decap_3
XPHY_65 VGND VGND VPWR VPWR sky130_fd_sc_hd__decap_3
XPHY_54 VGND VGND VPWR VPWR sky130_fd_sc_hd__decap_3
XPHY_10 VGND VGND VPWR VPWR sky130_fd_sc_hd__decap_3
XPHY_21 VGND VGND VPWR VPWR sky130_fd_sc_hd__decap_3
XPHY_32 VGND VGND VPWR VPWR sky130_fd_sc_hd__decap_3
XPHY_43 VGND VGND VPWR VPWR sky130_fd_sc_hd__decap_3
XFILLER_0_8_191 VGND VGND VPWR VPWR sky130_fd_sc_hd__fill_2
XFILLER_0_27_223 VGND VGND VPWR VPWR sky130_fd_sc_hd__fill_1
XFILLER_0_6_139 VGND VGND VPWR VPWR sky130_fd_sc_hd__fill_1
Xoutput115 net115 VGND VGND VPWR VPWR S_AXI_RDATA[13] sky130_fd_sc_hd__buf_2
XFILLER_0_50_270 VGND VGND VPWR VPWR sky130_fd_sc_hd__fill_1
X_2553_ _0455_ _0441_ _0729_ _0733_ _0725_ VGND VGND VPWR VPWR _0742_ sky130_fd_sc_hd__o221a_1
Xoutput126 net126 VGND VGND VPWR VPWR S_AXI_RDATA[23] sky130_fd_sc_hd__clkbuf_4
XFILLER_0_2_345 VGND VGND VPWR VPWR sky130_fd_sc_hd__decap_8
X_2622_ TX.baud_counter\[2\] _0810_ VGND VGND VPWR VPWR _0811_ sky130_fd_sc_hd__nor2_1
Xoutput137 net137 VGND VGND VPWR VPWR S_AXI_RDATA[4] sky130_fd_sc_hd__clkbuf_4
X_3671_ clknet_leaf_19_S_AXI_ACLK _0236_ net150 VGND VGND VPWR VPWR TX.baud_counter\[2\]
+ sky130_fd_sc_hd__dfrtp_4
XFILLER_0_49_6 VGND VGND VPWR VPWR sky130_fd_sc_hd__decap_6
X_3105_ RX.bit_idx\[1\] _0970_ _1176_ _1240_ RX.bit_idx\[2\] VGND VGND VPWR VPWR _1246_
+ sky130_fd_sc_hd__a41o_1
X_2484_ RX.uart_cpb\[14\] _0582_ VGND VGND VPWR VPWR _0673_ sky130_fd_sc_hd__nand2_1
X_3036_ _1153_ _1195_ VGND VGND VPWR VPWR _1197_ sky130_fd_sc_hd__nor2_1
XFILLER_0_5_161 VGND VGND VPWR VPWR sky130_fd_sc_hd__fill_2
Xinput17 S_AXI_ARADDR[24] VGND VGND VPWR VPWR net17 sky130_fd_sc_hd__buf_1
Xinput28 S_AXI_ARADDR[5] VGND VGND VPWR VPWR net28 sky130_fd_sc_hd__buf_1
XFILLER_0_24_259 VGND VGND VPWR VPWR sky130_fd_sc_hd__fill_2
XFILLER_0_24_204 VGND VGND VPWR VPWR sky130_fd_sc_hd__decap_4
Xinput39 S_AXI_AWADDR[13] VGND VGND VPWR VPWR net39 sky130_fd_sc_hd__clkbuf_1
X_1984_ _1667_ RX.rx_shifter\[11\] _1672_ uart_rdr\[11\] VGND VGND VPWR VPWR _1675_
+ sky130_fd_sc_hd__a22o_1
X_3654_ clknet_leaf_11_S_AXI_ACLK _0219_ VGND VGND VPWR VPWR RX.uart_cpb\[12\] sky130_fd_sc_hd__dfxtp_4
X_2536_ RX.uart_cpb\[27\] _1625_ VGND VGND VPWR VPWR _0725_ sky130_fd_sc_hd__nand2_1
X_2605_ _0687_ VGND VGND VPWR VPWR _0794_ sky130_fd_sc_hd__inv_2
X_2467_ _0510_ VGND VGND VPWR VPWR _0656_ sky130_fd_sc_hd__inv_2
XFILLER_0_2_197 VGND VGND VPWR VPWR sky130_fd_sc_hd__fill_1
XFILLER_0_2_186 VGND VGND VPWR VPWR sky130_fd_sc_hd__fill_2
X_3585_ clknet_leaf_21_S_AXI_ACLK _0150_ net149 VGND VGND VPWR VPWR RX.baud_cnt\[18\]
+ sky130_fd_sc_hd__dfrtp_4
X_2398_ _0555_ _0586_ _0557_ VGND VGND VPWR VPWR _0587_ sky130_fd_sc_hd__a21oi_1
X_3019_ _1160_ _1184_ VGND VGND VPWR VPWR _1185_ sky130_fd_sc_hd__nor2_1
Xfanout161 net162 VGND VGND VPWR VPWR net161 sky130_fd_sc_hd__clkbuf_4
Xfanout150 net153 VGND VGND VPWR VPWR net150 sky130_fd_sc_hd__clkbuf_4
XFILLER_0_44_29 VGND VGND VPWR VPWR sky130_fd_sc_hd__fill_1
XFILLER_0_52_354 VGND VGND VPWR VPWR sky130_fd_sc_hd__fill_1
XFILLER_0_8_29 VGND VGND VPWR VPWR sky130_fd_sc_hd__fill_1
X_2321_ RX.uart_cpb\[11\] RX.uart_cpb\[10\] VGND VGND VPWR VPWR _0510_ sky130_fd_sc_hd__nand2_1
X_3370_ _1364_ _1417_ _1419_ _1403_ net286 VGND VGND VPWR VPWR _0257_ sky130_fd_sc_hd__a32o_1
XFILLER_0_12_229 VGND VGND VPWR VPWR sky130_fd_sc_hd__fill_2
XFILLER_0_33_9 VGND VGND VPWR VPWR sky130_fd_sc_hd__decap_4
X_2183_ TX.baud_counter\[11\] _0390_ VGND VGND VPWR VPWR _0394_ sky130_fd_sc_hd__or2_1
XFILLER_0_18_52 VGND VGND VPWR VPWR sky130_fd_sc_hd__fill_1
XFILLER_0_18_85 VGND VGND VPWR VPWR sky130_fd_sc_hd__decap_3
X_2252_ TX.baud_counter\[28\] _0456_ _0444_ TX.baud_counter\[27\] _0462_ VGND VGND
+ VPWR VPWR _0463_ sky130_fd_sc_hd__o221a_1
XFILLER_0_34_51 VGND VGND VPWR VPWR sky130_fd_sc_hd__fill_1
X_1898_ uart_rdr\[21\] _1580_ _1590_ VGND VGND VPWR VPWR _1611_ sky130_fd_sc_hd__a21bo_1
X_3637_ clknet_leaf_4_S_AXI_ACLK _0202_ VGND VGND VPWR VPWR RX.uart_cpb\[27\] sky130_fd_sc_hd__dfxtp_2
X_1967_ _1646_ RX.rx_shifter\[6\] _1649_ uart_rdr\[6\] VGND VGND VPWR VPWR _1663_
+ sky130_fd_sc_hd__a22o_1
X_3706_ clknet_leaf_13_S_AXI_ACLK _0271_ net157 VGND VGND VPWR VPWR TX.data_latch\[5\]
+ sky130_fd_sc_hd__dfrtp_1
X_3499_ clknet_leaf_2_S_AXI_ACLK _0064_ VGND VGND VPWR VPWR uart_rdr\[24\] sky130_fd_sc_hd__dfxtp_1
X_2519_ _0573_ _0569_ VGND VGND VPWR VPWR _0708_ sky130_fd_sc_hd__or2_1
X_3568_ clknet_leaf_16_S_AXI_ACLK _0133_ net158 VGND VGND VPWR VPWR RX.baud_cnt\[1\]
+ sky130_fd_sc_hd__dfrtp_4
XFILLER_0_38_148 VGND VGND VPWR VPWR sky130_fd_sc_hd__fill_2
XFILLER_0_34_354 VGND VGND VPWR VPWR sky130_fd_sc_hd__decap_3
Xhold6 net113 VGND VGND VPWR VPWR net173 sky130_fd_sc_hd__dlygate4sd3_1
X_2870_ _1038_ _1046_ VGND VGND VPWR VPWR _1047_ sky130_fd_sc_hd__nor2_1
X_1752_ net223 _1483_ VGND VGND VPWR VPWR _1490_ sky130_fd_sc_hd__or2_1
X_1821_ TX.data_latch_next\[6\] _1507_ _1509_ RX.uart_stp\[6\] VGND VGND VPWR VPWR
+ _1549_ sky130_fd_sc_hd__a22o_1
X_3422_ net101 _1450_ _1453_ _1336_ VGND VGND VPWR VPWR _0275_ sky130_fd_sc_hd__o211a_1
X_2304_ net101 _0496_ _0499_ _0487_ VGND VGND VPWR VPWR _0111_ sky130_fd_sc_hd__o211a_1
X_3353_ TX.baud_counter\[19\] _1405_ _1352_ VGND VGND VPWR VPWR _1407_ sky130_fd_sc_hd__a21oi_1
X_3284_ _1350_ _1351_ _1354_ _1355_ TX.baud_counter\[1\] VGND VGND VPWR VPWR _0235_
+ sky130_fd_sc_hd__a32o_1
XFILLER_0_45_94 VGND VGND VPWR VPWR sky130_fd_sc_hd__fill_2
X_2166_ TX.baud_counter\[6\] _0372_ _0376_ TX.baud_counter\[7\] VGND VGND VPWR VPWR
+ _0377_ sky130_fd_sc_hd__a22o_1
X_2097_ net97 _0309_ _0318_ _0296_ VGND VGND VPWR VPWR _0085_ sky130_fd_sc_hd__o211a_1
X_2235_ _0436_ _0440_ _0445_ VGND VGND VPWR VPWR _0446_ sky130_fd_sc_hd__a21o_1
X_2999_ _0922_ _1166_ RX.baud_cnt\[4\] VGND VGND VPWR VPWR _1170_ sky130_fd_sc_hd__a21oi_1
XFILLER_0_0_63 VGND VGND VPWR VPWR sky130_fd_sc_hd__decap_3
XFILLER_0_16_332 VGND VGND VPWR VPWR sky130_fd_sc_hd__fill_2
XFILLER_0_31_335 VGND VGND VPWR VPWR sky130_fd_sc_hd__fill_1
XFILLER_0_3_281 VGND VGND VPWR VPWR sky130_fd_sc_hd__fill_2
XFILLER_0_22_302 VGND VGND VPWR VPWR sky130_fd_sc_hd__fill_1
XFILLER_0_1_218 VGND VGND VPWR VPWR sky130_fd_sc_hd__fill_2
X_2020_ net155 VGND VGND VPWR VPWR _1700_ sky130_fd_sc_hd__clkbuf_2
X_2922_ _0902_ _0798_ _1097_ _1098_ VGND VGND VPWR VPWR _1099_ sky130_fd_sc_hd__o211ai_1
XFILLER_0_15_53 VGND VGND VPWR VPWR sky130_fd_sc_hd__decap_3
X_2853_ RX.baud_cnt\[11\] VGND VGND VPWR VPWR _1030_ sky130_fd_sc_hd__inv_2
X_1735_ net46 net35 _1475_ _1476_ VGND VGND VPWR VPWR _1477_ sky130_fd_sc_hd__or4_1
X_2784_ RX.baud_cnt\[26\] _0439_ _0957_ _0958_ _0960_ VGND VGND VPWR VPWR _0961_ sky130_fd_sc_hd__o221a_1
X_1804_ RX.uart_cpb\[3\] VGND VGND VPWR VPWR _1535_ sky130_fd_sc_hd__clkbuf_4
X_3405_ net291 VGND VGND VPWR VPWR _0268_ sky130_fd_sc_hd__clkbuf_1
XFILLER_0_0_251 VGND VGND VPWR VPWR sky130_fd_sc_hd__fill_1
X_3336_ _1369_ _1392_ _1394_ _1368_ net285 VGND VGND VPWR VPWR _0248_ sky130_fd_sc_hd__a32o_1
X_3267_ TX.tx_enable _1342_ VGND VGND VPWR VPWR _1343_ sky130_fd_sc_hd__nor2_2
X_3198_ _0748_ _1291_ VGND VGND VPWR VPWR _1300_ sky130_fd_sc_hd__nand2_1
X_2218_ RX.uart_cpb\[23\] _0345_ VGND VGND VPWR VPWR _0429_ sky130_fd_sc_hd__or2_2
X_2149_ TX.baud_counter\[4\] _0359_ _0358_ TX.baud_counter\[5\] VGND VGND VPWR VPWR
+ _0360_ sky130_fd_sc_hd__a22o_1
Xuart_top_164 VGND VGND VPWR VPWR uart_top_164/HI S_AXI_BRESP[0] sky130_fd_sc_hd__conb_1
XFILLER_0_16_184 VGND VGND VPWR VPWR sky130_fd_sc_hd__decap_8
XFILLER_0_31_198 VGND VGND VPWR VPWR sky130_fd_sc_hd__decap_3
XFILLER_0_52_29 VGND VGND VPWR VPWR sky130_fd_sc_hd__decap_3
X_3121_ _1257_ VGND VGND VPWR VPWR _0170_ sky130_fd_sc_hd__clkbuf_1
X_2003_ _1667_ RX.rx_shifter\[17\] _1672_ uart_rdr\[17\] VGND VGND VPWR VPWR _1688_
+ sky130_fd_sc_hd__a22o_1
XFILLER_0_26_85 VGND VGND VPWR VPWR sky130_fd_sc_hd__decap_3
X_3052_ RX.baud_cnt\[18\] _1206_ _1208_ VGND VGND VPWR VPWR _0150_ sky130_fd_sc_hd__o21a_1
XFILLER_0_45_279 VGND VGND VPWR VPWR sky130_fd_sc_hd__fill_1
X_2836_ _0999_ _1001_ _1010_ _1012_ VGND VGND VPWR VPWR _1013_ sky130_fd_sc_hd__or4_1
X_2905_ _1081_ VGND VGND VPWR VPWR _1082_ sky130_fd_sc_hd__inv_2
X_2698_ _0307_ _0481_ VGND VGND VPWR VPWR _0884_ sky130_fd_sc_hd__nor2_2
X_1718_ TX.bit_index\[2\] _1460_ VGND VGND VPWR VPWR _1461_ sky130_fd_sc_hd__and2b_1
X_2767_ RX.baud_cnt\[22\] _0347_ _0901_ _0942_ _0943_ VGND VGND VPWR VPWR _0944_ sky130_fd_sc_hd__a2111o_1
XTAP_393 VGND VPWR sky130_fd_sc_hd__tapvpwrvgnd_1
XTAP_382 VGND VPWR sky130_fd_sc_hd__tapvpwrvgnd_1
XTAP_371 VGND VPWR sky130_fd_sc_hd__tapvpwrvgnd_1
XTAP_360 VGND VPWR sky130_fd_sc_hd__tapvpwrvgnd_1
X_3319_ TX.baud_counter\[10\] _1379_ _1381_ VGND VGND VPWR VPWR _1382_ sky130_fd_sc_hd__a21oi_1
XPHY_99 VGND VGND VPWR VPWR sky130_fd_sc_hd__decap_3
XPHY_88 VGND VGND VPWR VPWR sky130_fd_sc_hd__decap_3
XPHY_77 VGND VGND VPWR VPWR sky130_fd_sc_hd__decap_3
XPHY_66 VGND VGND VPWR VPWR sky130_fd_sc_hd__decap_3
XPHY_55 VGND VGND VPWR VPWR sky130_fd_sc_hd__decap_3
XPHY_11 VGND VGND VPWR VPWR sky130_fd_sc_hd__decap_3
XPHY_22 VGND VGND VPWR VPWR sky130_fd_sc_hd__decap_3
XPHY_33 VGND VGND VPWR VPWR sky130_fd_sc_hd__decap_3
XPHY_44 VGND VGND VPWR VPWR sky130_fd_sc_hd__decap_3
XFILLER_0_51_205 VGND VGND VPWR VPWR sky130_fd_sc_hd__fill_2
X_3670_ clknet_leaf_19_S_AXI_ACLK _0235_ net150 VGND VGND VPWR VPWR TX.baud_counter\[1\]
+ sky130_fd_sc_hd__dfrtp_4
XFILLER_0_12_76 VGND VGND VPWR VPWR sky130_fd_sc_hd__fill_2
Xoutput127 net127 VGND VGND VPWR VPWR S_AXI_RDATA[24] sky130_fd_sc_hd__clkbuf_4
Xoutput116 net116 VGND VGND VPWR VPWR S_AXI_RDATA[14] sky130_fd_sc_hd__clkbuf_4
X_2552_ _0739_ _0740_ VGND VGND VPWR VPWR _0741_ sky130_fd_sc_hd__nand2_1
X_2483_ _0576_ _0595_ VGND VGND VPWR VPWR _0672_ sky130_fd_sc_hd__nand2_1
Xoutput138 net138 VGND VGND VPWR VPWR S_AXI_RDATA[5] sky130_fd_sc_hd__clkbuf_4
XFILLER_0_2_357 VGND VGND VPWR VPWR sky130_fd_sc_hd__fill_1
X_2621_ _0624_ _0628_ VGND VGND VPWR VPWR _0810_ sky130_fd_sc_hd__xor2_2
XFILLER_0_10_102 VGND VGND VPWR VPWR sky130_fd_sc_hd__fill_1
X_3104_ _0971_ _1238_ VGND VGND VPWR VPWR _1245_ sky130_fd_sc_hd__nor2_1
X_3035_ _1194_ _1195_ _1196_ _1186_ _0910_ VGND VGND VPWR VPWR _0145_ sky130_fd_sc_hd__a32o_1
XFILLER_0_53_72 VGND VGND VPWR VPWR sky130_fd_sc_hd__fill_1
X_2819_ RX.uart_cpb\[24\] _0995_ VGND VGND VPWR VPWR _0996_ sky130_fd_sc_hd__nor2_1
XTAP_190 VGND VPWR sky130_fd_sc_hd__tapvpwrvgnd_1
Xinput18 S_AXI_ARADDR[25] VGND VGND VPWR VPWR net18 sky130_fd_sc_hd__buf_1
Xinput29 S_AXI_ARADDR[6] VGND VGND VPWR VPWR net29 sky130_fd_sc_hd__buf_1
X_1983_ _1674_ VGND VGND VPWR VPWR _0050_ sky130_fd_sc_hd__clkbuf_1
X_3653_ clknet_leaf_5_S_AXI_ACLK _0218_ VGND VGND VPWR VPWR RX.uart_cpb\[11\] sky130_fd_sc_hd__dfxtp_4
X_2604_ _0577_ _0677_ _0678_ _0679_ VGND VGND VPWR VPWR _0793_ sky130_fd_sc_hd__a31oi_2
XFILLER_0_48_50 VGND VGND VPWR VPWR sky130_fd_sc_hd__fill_1
X_2535_ RX.uart_cpb\[26\] VGND VGND VPWR VPWR _0724_ sky130_fd_sc_hd__inv_2
X_2466_ _0510_ _0651_ _0512_ VGND VGND VPWR VPWR _0655_ sky130_fd_sc_hd__a21bo_1
X_3584_ clknet_leaf_21_S_AXI_ACLK _0149_ net149 VGND VGND VPWR VPWR RX.baud_cnt\[17\]
+ sky130_fd_sc_hd__dfrtp_1
X_2397_ _0561_ _0585_ _0556_ VGND VGND VPWR VPWR _0586_ sky130_fd_sc_hd__a21o_1
X_3018_ RX.baud_cnt\[9\] _1181_ VGND VGND VPWR VPWR _1184_ sky130_fd_sc_hd__and2_1
XFILLER_0_46_352 VGND VGND VPWR VPWR sky130_fd_sc_hd__fill_2
Xfanout162 net163 VGND VGND VPWR VPWR net162 sky130_fd_sc_hd__buf_2
Xfanout151 net153 VGND VGND VPWR VPWR net151 sky130_fd_sc_hd__clkbuf_4
XFILLER_0_56_138 VGND VGND VPWR VPWR sky130_fd_sc_hd__fill_2
XFILLER_0_56_149 VGND VGND VPWR VPWR sky130_fd_sc_hd__fill_1
X_2320_ RX.uart_cpb\[22\] RX.uart_cpb\[20\] RX.uart_cpb\[21\] VGND VGND VPWR VPWR
+ _0509_ sky130_fd_sc_hd__o21ai_1
X_2251_ TX.baud_counter\[29\] _0458_ VGND VGND VPWR VPWR _0462_ sky130_fd_sc_hd__or2_1
X_2182_ _0392_ _0338_ VGND VGND VPWR VPWR _0393_ sky130_fd_sc_hd__xnor2_2
XFILLER_0_28_363 VGND VGND VPWR VPWR sky130_fd_sc_hd__fill_1
X_1966_ _1662_ VGND VGND VPWR VPWR _0045_ sky130_fd_sc_hd__clkbuf_1
X_1897_ TX.uart_tdr\[21\] _1604_ _1605_ RX.uart_stp\[21\] VGND VGND VPWR VPWR _1610_
+ sky130_fd_sc_hd__a22o_1
X_3636_ clknet_leaf_0_S_AXI_ACLK _0201_ VGND VGND VPWR VPWR RX.uart_cpb\[26\] sky130_fd_sc_hd__dfxtp_1
X_3567_ clknet_leaf_19_S_AXI_ACLK _0132_ net151 VGND VGND VPWR VPWR RX.baud_cnt\[0\]
+ sky130_fd_sc_hd__dfrtp_4
X_3705_ clknet_leaf_14_S_AXI_ACLK _0270_ net163 VGND VGND VPWR VPWR TX.data_latch\[4\]
+ sky130_fd_sc_hd__dfrtp_1
X_3498_ clknet_leaf_2_S_AXI_ACLK _0063_ VGND VGND VPWR VPWR uart_rdr\[23\] sky130_fd_sc_hd__dfxtp_1
X_2518_ _0705_ _0706_ VGND VGND VPWR VPWR _0707_ sky130_fd_sc_hd__nand2_1
X_2449_ _0608_ _0636_ _0637_ VGND VGND VPWR VPWR _0638_ sky130_fd_sc_hd__a21oi_1
Xhold7 net135 VGND VGND VPWR VPWR net174 sky130_fd_sc_hd__dlygate4sd3_1
X_1820_ _1534_ net169 _1524_ _1548_ VGND VGND VPWR VPWR _0013_ sky130_fd_sc_hd__o211a_1
XFILLER_0_52_141 VGND VGND VPWR VPWR sky130_fd_sc_hd__fill_1
X_1751_ net89 _1482_ _1489_ _1486_ VGND VGND VPWR VPWR _0003_ sky130_fd_sc_hd__o211a_1
X_3421_ net211 _1451_ VGND VGND VPWR VPWR _1453_ sky130_fd_sc_hd__or2_1
X_2303_ net245 _0497_ VGND VGND VPWR VPWR _0499_ sky130_fd_sc_hd__or2_1
X_3283_ _1343_ VGND VGND VPWR VPWR _1355_ sky130_fd_sc_hd__clkbuf_4
X_3352_ _1369_ _1404_ _1406_ _1403_ TX.baud_counter\[18\] VGND VGND VPWR VPWR _0252_
+ sky130_fd_sc_hd__a32o_1
X_2234_ TX.baud_counter\[26\] _0439_ _0444_ TX.baud_counter\[27\] VGND VGND VPWR VPWR
+ _0445_ sky130_fd_sc_hd__a22o_1
XFILLER_0_0_42 VGND VGND VPWR VPWR sky130_fd_sc_hd__decap_3
X_2165_ _0336_ _0375_ VGND VGND VPWR VPWR _0376_ sky130_fd_sc_hd__and2_1
X_2096_ net289 _0310_ VGND VGND VPWR VPWR _0318_ sky130_fd_sc_hd__or2_1
X_1949_ _1635_ _1650_ VGND VGND VPWR VPWR _1651_ sky130_fd_sc_hd__and2_1
X_2998_ _1159_ _1168_ _1169_ _1154_ _0922_ VGND VGND VPWR VPWR _0135_ sky130_fd_sc_hd__a32o_1
X_3619_ clknet_leaf_7_S_AXI_ACLK _0184_ net159 VGND VGND VPWR VPWR RX.rx_shifter\[17\]
+ sky130_fd_sc_hd__dfrtp_1
XFILLER_0_19_182 VGND VGND VPWR VPWR sky130_fd_sc_hd__fill_1
XFILLER_0_15_21 VGND VGND VPWR VPWR sky130_fd_sc_hd__fill_1
X_1803_ _1495_ VGND VGND VPWR VPWR _1534_ sky130_fd_sc_hd__clkbuf_4
X_2783_ _0959_ _0444_ VGND VGND VPWR VPWR _0960_ sky130_fd_sc_hd__or2_1
X_2921_ RX.baud_cnt\[16\] _0852_ VGND VGND VPWR VPWR _1098_ sky130_fd_sc_hd__nand2_1
X_2852_ _0404_ RX.baud_cnt\[14\] _0910_ _0403_ VGND VGND VPWR VPWR _1029_ sky130_fd_sc_hd__a22o_1
XFILLER_0_40_166 VGND VGND VPWR VPWR sky130_fd_sc_hd__decap_4
X_3404_ TX.data_latch_next\[2\] net290 _1440_ VGND VGND VPWR VPWR _1443_ sky130_fd_sc_hd__mux2_1
XFILLER_0_0_263 VGND VGND VPWR VPWR sky130_fd_sc_hd__fill_2
X_1734_ net66 net65 net37 net36 VGND VGND VPWR VPWR _1476_ sky130_fd_sc_hd__or4_1
X_3197_ net91 _1292_ _1299_ _0890_ VGND VGND VPWR VPWR _0204_ sky130_fd_sc_hd__o211a_1
X_2217_ RX.uart_cpb\[24\] VGND VGND VPWR VPWR _0428_ sky130_fd_sc_hd__inv_2
X_3335_ _1381_ _1393_ VGND VGND VPWR VPWR _1394_ sky130_fd_sc_hd__nor2_1
X_3266_ _1341_ VGND VGND VPWR VPWR _1342_ sky130_fd_sc_hd__clkbuf_4
XFILLER_0_48_277 VGND VGND VPWR VPWR sky130_fd_sc_hd__decap_3
X_2079_ _1474_ _0286_ VGND VGND VPWR VPWR _0306_ sky130_fd_sc_hd__or2_1
X_2148_ _0300_ _0334_ VGND VGND VPWR VPWR _0359_ sky130_fd_sc_hd__xnor2_2
Xuart_top_165 VGND VGND VPWR VPWR uart_top_165/HI S_AXI_BRESP[1] sky130_fd_sc_hd__conb_1
XFILLER_0_52_19 VGND VGND VPWR VPWR sky130_fd_sc_hd__fill_1
XFILLER_0_22_177 VGND VGND VPWR VPWR sky130_fd_sc_hd__fill_1
X_3120_ net107 net325 _1256_ VGND VGND VPWR VPWR _1257_ sky130_fd_sc_hd__mux2_1
X_3051_ _1176_ _1207_ _1152_ VGND VGND VPWR VPWR _1208_ sky130_fd_sc_hd__o21bai_1
X_2002_ _1687_ VGND VGND VPWR VPWR _0056_ sky130_fd_sc_hd__clkbuf_1
XFILLER_0_26_97 VGND VGND VPWR VPWR sky130_fd_sc_hd__decap_8
XFILLER_0_26_53 VGND VGND VPWR VPWR sky130_fd_sc_hd__decap_3
XFILLER_0_45_225 VGND VGND VPWR VPWR sky130_fd_sc_hd__decap_3
X_2835_ _1002_ RX.baud_cnt\[16\] _0996_ _1003_ _1011_ VGND VGND VPWR VPWR _1012_ sky130_fd_sc_hd__a2111o_1
X_2766_ RX.baud_cnt\[16\] _0409_ VGND VGND VPWR VPWR _0943_ sky130_fd_sc_hd__and2_1
X_2904_ RX.baud_cnt\[9\] _0807_ _0832_ RX.baud_cnt\[8\] VGND VGND VPWR VPWR _1081_
+ sky130_fd_sc_hd__o22a_1
X_2697_ _0882_ VGND VGND VPWR VPWR _0883_ sky130_fd_sc_hd__buf_2
XTAP_350 VGND VPWR sky130_fd_sc_hd__tapvpwrvgnd_1
X_1717_ TX.data_latch\[0\] TX.data_latch\[1\] TX.data_latch\[2\] TX.data_latch\[3\]
+ TX.bit_index\[0\] TX.bit_index\[1\] VGND VGND VPWR VPWR _1460_ sky130_fd_sc_hd__mux4_1
XFILLER_0_6_52 VGND VGND VPWR VPWR sky130_fd_sc_hd__decap_3
X_3318_ _1352_ VGND VGND VPWR VPWR _1381_ sky130_fd_sc_hd__clkbuf_4
XFILLER_0_6_85 VGND VGND VPWR VPWR sky130_fd_sc_hd__fill_1
XTAP_394 VGND VPWR sky130_fd_sc_hd__tapvpwrvgnd_1
X_3249_ net87 _1328_ _1331_ _1322_ VGND VGND VPWR VPWR _0224_ sky130_fd_sc_hd__o211a_1
XTAP_383 VGND VPWR sky130_fd_sc_hd__tapvpwrvgnd_1
XTAP_372 VGND VPWR sky130_fd_sc_hd__tapvpwrvgnd_1
XTAP_361 VGND VPWR sky130_fd_sc_hd__tapvpwrvgnd_1
XPHY_12 VGND VGND VPWR VPWR sky130_fd_sc_hd__decap_3
XPHY_89 VGND VGND VPWR VPWR sky130_fd_sc_hd__decap_3
XPHY_78 VGND VGND VPWR VPWR sky130_fd_sc_hd__decap_3
XPHY_67 VGND VGND VPWR VPWR sky130_fd_sc_hd__decap_3
XPHY_56 VGND VGND VPWR VPWR sky130_fd_sc_hd__decap_3
XPHY_23 VGND VGND VPWR VPWR sky130_fd_sc_hd__decap_3
XPHY_34 VGND VGND VPWR VPWR sky130_fd_sc_hd__decap_3
XPHY_45 VGND VGND VPWR VPWR sky130_fd_sc_hd__decap_3
X_2620_ TX.baud_counter\[3\] _0808_ VGND VGND VPWR VPWR _0809_ sky130_fd_sc_hd__and2_1
XFILLER_0_50_261 VGND VGND VPWR VPWR sky130_fd_sc_hd__fill_1
X_2551_ RX.uart_cpb\[29\] RX.uart_cpb\[28\] VGND VGND VPWR VPWR _0740_ sky130_fd_sc_hd__nand2_1
X_2482_ _0538_ _0541_ _0546_ _0594_ VGND VGND VPWR VPWR _0671_ sky130_fd_sc_hd__and4_1
Xoutput117 net117 VGND VGND VPWR VPWR S_AXI_RDATA[15] sky130_fd_sc_hd__clkbuf_4
Xoutput128 net128 VGND VGND VPWR VPWR S_AXI_RDATA[25] sky130_fd_sc_hd__clkbuf_4
Xoutput139 net139 VGND VGND VPWR VPWR S_AXI_RDATA[6] sky130_fd_sc_hd__clkbuf_4
XFILLER_0_10_169 VGND VGND VPWR VPWR sky130_fd_sc_hd__fill_1
X_3103_ RX.bit_idx\[1\] _1241_ _1244_ VGND VGND VPWR VPWR _0165_ sky130_fd_sc_hd__a21o_1
X_3034_ _0910_ _1192_ _1163_ VGND VGND VPWR VPWR _1196_ sky130_fd_sc_hd__o21a_1
XFILLER_0_33_228 VGND VGND VPWR VPWR sky130_fd_sc_hd__fill_2
X_2818_ _0895_ VGND VGND VPWR VPWR _0995_ sky130_fd_sc_hd__inv_2
X_2749_ RX.baud_cnt\[2\] _0367_ _0924_ _0925_ VGND VGND VPWR VPWR _0926_ sky130_fd_sc_hd__a22o_1
Xclkbuf_leaf_14_S_AXI_ACLK clknet_1_1__leaf_S_AXI_ACLK VGND VGND VPWR VPWR clknet_leaf_14_S_AXI_ACLK
+ sky130_fd_sc_hd__clkbuf_16
XTAP_180 VGND VPWR sky130_fd_sc_hd__tapvpwrvgnd_1
XTAP_191 VGND VPWR sky130_fd_sc_hd__tapvpwrvgnd_1
Xinput19 S_AXI_ARADDR[26] VGND VGND VPWR VPWR net19 sky130_fd_sc_hd__buf_1
X_1982_ _1654_ _1673_ VGND VGND VPWR VPWR _1674_ sky130_fd_sc_hd__and2_1
X_3721_ net109 VGND VGND VPWR VPWR net144 sky130_fd_sc_hd__clkbuf_1
X_2534_ RX.uart_cpb\[25\] VGND VGND VPWR VPWR _0723_ sky130_fd_sc_hd__inv_2
X_3652_ clknet_leaf_11_S_AXI_ACLK _0217_ VGND VGND VPWR VPWR RX.uart_cpb\[10\] sky130_fd_sc_hd__dfxtp_4
XFILLER_0_23_261 VGND VGND VPWR VPWR sky130_fd_sc_hd__fill_2
XFILLER_0_2_122 VGND VGND VPWR VPWR sky130_fd_sc_hd__fill_2
X_3583_ clknet_leaf_21_S_AXI_ACLK _0148_ net150 VGND VGND VPWR VPWR RX.baud_cnt\[16\]
+ sky130_fd_sc_hd__dfrtp_4
X_2603_ _0784_ _0787_ _0788_ _0791_ VGND VGND VPWR VPWR _0792_ sky130_fd_sc_hd__and4b_1
X_2396_ _0548_ _0550_ _0554_ VGND VGND VPWR VPWR _0585_ sky130_fd_sc_hd__a21o_1
X_2465_ _0649_ _0312_ _0604_ _0385_ _0653_ VGND VGND VPWR VPWR _0654_ sky130_fd_sc_hd__o221a_1
X_3017_ RX.baud_cnt\[9\] _1181_ VGND VGND VPWR VPWR _1183_ sky130_fd_sc_hd__or2_1
Xfanout163 net33 VGND VGND VPWR VPWR net163 sky130_fd_sc_hd__buf_4
Xfanout152 net153 VGND VGND VPWR VPWR net152 sky130_fd_sc_hd__clkbuf_2
X_2250_ TX.baud_counter\[30\] _0453_ _0460_ VGND VGND VPWR VPWR _0461_ sky130_fd_sc_hd__o21a_1
X_2181_ RX.uart_cpb\[12\] VGND VGND VPWR VPWR _0392_ sky130_fd_sc_hd__inv_2
XFILLER_0_34_64 VPWR VGND VPWR VGND sky130_ef_sc_hd__decap_12
XFILLER_0_43_312 VGND VGND VPWR VPWR sky130_fd_sc_hd__fill_1
X_3704_ clknet_leaf_13_S_AXI_ACLK _0269_ net158 VGND VGND VPWR VPWR TX.data_latch\[3\]
+ sky130_fd_sc_hd__dfrtp_1
X_1965_ _1654_ _1661_ VGND VGND VPWR VPWR _1662_ sky130_fd_sc_hd__and2_1
X_3497_ clknet_leaf_3_S_AXI_ACLK _0062_ VGND VGND VPWR VPWR uart_rdr\[22\] sky130_fd_sc_hd__dfxtp_1
X_1896_ _1495_ VGND VGND VPWR VPWR _1609_ sky130_fd_sc_hd__clkbuf_4
X_3635_ clknet_leaf_0_S_AXI_ACLK _0200_ VGND VGND VPWR VPWR RX.uart_cpb\[25\] sky130_fd_sc_hd__dfxtp_2
X_3566_ clknet_leaf_5_S_AXI_ACLK _0131_ net159 VGND VGND VPWR VPWR RX.state\[1\] sky130_fd_sc_hd__dfrtp_4
X_2517_ RX.uart_cpb\[25\] RX.uart_cpb\[24\] VGND VGND VPWR VPWR _0706_ sky130_fd_sc_hd__nand2_1
X_2379_ RX.uart_cpb\[23\] RX.uart_cpb\[22\] VGND VGND VPWR VPWR _0568_ sky130_fd_sc_hd__or2_1
X_2448_ _1525_ _1535_ _0581_ _1541_ VGND VGND VPWR VPWR _0637_ sky130_fd_sc_hd__a22o_1
Xclkbuf_leaf_4_S_AXI_ACLK clknet_1_0__leaf_S_AXI_ACLK VGND VGND VPWR VPWR clknet_leaf_4_S_AXI_ACLK
+ sky130_fd_sc_hd__clkbuf_16
XFILLER_0_38_139 VGND VGND VPWR VPWR sky130_fd_sc_hd__fill_1
XFILLER_0_55_19 VPWR VGND VPWR VGND sky130_ef_sc_hd__decap_12
Xhold8 net131 VGND VGND VPWR VPWR net175 sky130_fd_sc_hd__dlygate4sd3_1
XFILLER_0_44_109 VGND VGND VPWR VPWR sky130_fd_sc_hd__decap_4
X_1750_ net222 _1483_ VGND VGND VPWR VPWR _1489_ sky130_fd_sc_hd__or2_1
XFILLER_0_52_197 VGND VGND VPWR VPWR sky130_fd_sc_hd__fill_1
X_3420_ net100 _1450_ _1452_ _1336_ VGND VGND VPWR VPWR _0274_ sky130_fd_sc_hd__o211a_1
X_3351_ _1381_ _1405_ VGND VGND VPWR VPWR _1406_ sky130_fd_sc_hd__nor2_1
XFILLER_0_20_11 VGND VGND VPWR VPWR sky130_fd_sc_hd__fill_2
X_2302_ net100 _0496_ _0498_ _0487_ VGND VGND VPWR VPWR _0110_ sky130_fd_sc_hd__o211a_1
X_2233_ _0441_ _0437_ _0443_ VGND VGND VPWR VPWR _0444_ sky130_fd_sc_hd__o21a_1
X_3282_ TX.baud_counter\[0\] TX.baud_counter\[1\] _1353_ VGND VGND VPWR VPWR _1354_
+ sky130_fd_sc_hd__a21oi_1
X_2164_ RX.uart_cpb\[6\] _0356_ _1553_ VGND VGND VPWR VPWR _0375_ sky130_fd_sc_hd__o21ai_1
X_2095_ net96 _0309_ _0317_ _0296_ VGND VGND VPWR VPWR _0084_ sky130_fd_sc_hd__o211a_1
X_1879_ _1571_ net172 _1561_ _1595_ VGND VGND VPWR VPWR _0025_ sky130_fd_sc_hd__o211a_1
X_1948_ _1646_ RX.rx_shifter\[0\] _1649_ uart_rdr\[0\] VGND VGND VPWR VPWR _1650_
+ sky130_fd_sc_hd__a22o_1
XFILLER_0_28_194 VGND VGND VPWR VPWR sky130_fd_sc_hd__fill_2
X_2997_ _0922_ _1166_ _1163_ VGND VGND VPWR VPWR _1169_ sky130_fd_sc_hd__o21a_1
X_3618_ clknet_leaf_7_S_AXI_ACLK _0183_ net159 VGND VGND VPWR VPWR RX.rx_shifter\[16\]
+ sky130_fd_sc_hd__dfrtp_1
X_3549_ clknet_leaf_5_S_AXI_ACLK _0114_ VGND VGND VPWR VPWR TX.uart_tdr\[12\] sky130_fd_sc_hd__dfxtp_1
XFILLER_0_26_109 VGND VGND VPWR VPWR sky130_fd_sc_hd__fill_1
XFILLER_0_15_33 VGND VGND VPWR VPWR sky130_fd_sc_hd__decap_4
XFILLER_0_15_99 VGND VGND VPWR VPWR sky130_fd_sc_hd__fill_1
X_2920_ RX.baud_cnt\[16\] _0852_ VGND VGND VPWR VPWR _1097_ sky130_fd_sc_hd__or2_1
XFILLER_0_57_278 VGND VGND VPWR VPWR sky130_fd_sc_hd__fill_2
X_2851_ _1015_ _1025_ _1027_ VGND VGND VPWR VPWR _1028_ sky130_fd_sc_hd__o21ba_1
X_1802_ _1495_ net192 _1531_ _1533_ _1524_ VGND VGND VPWR VPWR _0010_ sky130_fd_sc_hd__o221a_1
X_2782_ RX.baud_cnt\[27\] VGND VGND VPWR VPWR _0959_ sky130_fd_sc_hd__buf_2
X_1733_ net39 net41 net40 net38 VGND VGND VPWR VPWR _1475_ sky130_fd_sc_hd__or4bb_1
XFILLER_0_40_112 VGND VGND VPWR VPWR sky130_fd_sc_hd__fill_1
X_3403_ net308 VGND VGND VPWR VPWR _0267_ sky130_fd_sc_hd__clkbuf_1
XFILLER_0_0_297 VGND VGND VPWR VPWR sky130_fd_sc_hd__decap_6
XFILLER_0_0_286 VGND VGND VPWR VPWR sky130_fd_sc_hd__fill_2
X_3334_ TX.baud_counter\[14\] TX.baud_counter\[13\] _1388_ VGND VGND VPWR VPWR _1393_
+ sky130_fd_sc_hd__and3_1
X_3196_ _0749_ _1291_ VGND VGND VPWR VPWR _1299_ sky130_fd_sc_hd__nand2_1
X_2147_ _0356_ _0357_ VGND VGND VPWR VPWR _0358_ sky130_fd_sc_hd__and2_1
X_3265_ TX.state\[1\] TX.state\[0\] VGND VGND VPWR VPWR _1341_ sky130_fd_sc_hd__or2_1
X_2216_ TX.baud_counter\[22\] _0347_ _0349_ TX.baud_counter\[23\] _0426_ VGND VGND
+ VPWR VPWR _0427_ sky130_fd_sc_hd__a221o_1
X_2078_ net99 _0290_ _0305_ _0296_ VGND VGND VPWR VPWR _0079_ sky130_fd_sc_hd__o211a_1
Xuart_top_166 VGND VGND VPWR VPWR uart_top_166/HI S_AXI_RRESP[0] sky130_fd_sc_hd__conb_1
XFILLER_0_16_175 VGND VGND VPWR VPWR sky130_fd_sc_hd__fill_2
XFILLER_0_39_278 VGND VGND VPWR VPWR sky130_fd_sc_hd__fill_2
X_2001_ _1677_ _1686_ VGND VGND VPWR VPWR _1687_ sky130_fd_sc_hd__and2_1
X_3050_ _0998_ _1204_ VGND VGND VPWR VPWR _1207_ sky130_fd_sc_hd__nor2_1
X_2903_ RX.baud_cnt\[10\] _0836_ _0807_ RX.baud_cnt\[9\] VGND VGND VPWR VPWR _1080_
+ sky130_fd_sc_hd__a22o_1
X_2696_ _0307_ _0481_ VGND VGND VPWR VPWR _0882_ sky130_fd_sc_hd__or2_1
X_2834_ _0350_ RX.baud_cnt\[20\] _0904_ _0352_ _1007_ VGND VGND VPWR VPWR _1011_ sky130_fd_sc_hd__a221o_1
XFILLER_0_5_334 VGND VGND VPWR VPWR sky130_fd_sc_hd__fill_2
XFILLER_0_13_167 VGND VGND VPWR VPWR sky130_fd_sc_hd__fill_1
X_2765_ RX.baud_cnt\[16\] _0409_ _0414_ _0902_ VGND VGND VPWR VPWR _0942_ sky130_fd_sc_hd__o22ai_1
XTAP_384 VGND VPWR sky130_fd_sc_hd__tapvpwrvgnd_1
XTAP_373 VGND VPWR sky130_fd_sc_hd__tapvpwrvgnd_1
XTAP_362 VGND VPWR sky130_fd_sc_hd__tapvpwrvgnd_1
XTAP_351 VGND VPWR sky130_fd_sc_hd__tapvpwrvgnd_1
XTAP_340 VGND VPWR sky130_fd_sc_hd__tapvpwrvgnd_1
X_3317_ _1369_ _1378_ _1380_ _1368_ net296 VGND VGND VPWR VPWR _0243_ sky130_fd_sc_hd__a32o_1
X_3179_ _1288_ VGND VGND VPWR VPWR _0197_ sky130_fd_sc_hd__clkbuf_1
XTAP_395 VGND VPWR sky130_fd_sc_hd__tapvpwrvgnd_1
X_3248_ net280 _1329_ VGND VGND VPWR VPWR _1331_ sky130_fd_sc_hd__or2_1
XPHY_13 VGND VGND VPWR VPWR sky130_fd_sc_hd__decap_3
XPHY_24 VGND VGND VPWR VPWR sky130_fd_sc_hd__decap_3
XPHY_35 VGND VGND VPWR VPWR sky130_fd_sc_hd__decap_3
XPHY_46 VGND VGND VPWR VPWR sky130_fd_sc_hd__decap_3
XPHY_79 VGND VGND VPWR VPWR sky130_fd_sc_hd__decap_3
XPHY_68 VGND VGND VPWR VPWR sky130_fd_sc_hd__decap_3
XPHY_57 VGND VGND VPWR VPWR sky130_fd_sc_hd__decap_3
XFILLER_0_4_3 VPWR VGND VPWR VGND sky130_ef_sc_hd__decap_12
XFILLER_0_27_204 VGND VGND VPWR VPWR sky130_fd_sc_hd__fill_1
X_2550_ RX.uart_cpb\[29\] RX.uart_cpb\[28\] VGND VGND VPWR VPWR _0739_ sky130_fd_sc_hd__or2_1
Xoutput118 net118 VGND VGND VPWR VPWR S_AXI_RDATA[16] sky130_fd_sc_hd__buf_2
Xoutput129 net129 VGND VGND VPWR VPWR S_AXI_RDATA[26] sky130_fd_sc_hd__clkbuf_4
X_2481_ RX.uart_cpb\[13\] VGND VGND VPWR VPWR _0670_ sky130_fd_sc_hd__inv_2
X_3102_ _1238_ _1157_ _1242_ _1243_ VGND VGND VPWR VPWR _1244_ sky130_fd_sc_hd__and4b_1
X_3033_ _0910_ _1192_ VGND VGND VPWR VPWR _1195_ sky130_fd_sc_hd__nand2_1
XFILLER_0_33_207 VGND VGND VPWR VPWR sky130_fd_sc_hd__decap_6
XFILLER_0_18_204 VGND VGND VPWR VPWR sky130_fd_sc_hd__fill_2
X_2817_ _0976_ _0980_ _0993_ VGND VGND VPWR VPWR _0994_ sky130_fd_sc_hd__or3_1
X_2748_ _1522_ RX.baud_cnt\[0\] _0363_ RX.baud_cnt\[1\] VGND VGND VPWR VPWR _0925_
+ sky130_fd_sc_hd__a22o_1
X_2679_ TX.baud_counter\[27\] _0866_ _0771_ TX.baud_counter\[28\] VGND VGND VPWR VPWR
+ _0868_ sky130_fd_sc_hd__o22a_1
XTAP_170 VGND VPWR sky130_fd_sc_hd__tapvpwrvgnd_1
XTAP_181 VGND VPWR sky130_fd_sc_hd__tapvpwrvgnd_1
XTAP_192 VGND VPWR sky130_fd_sc_hd__tapvpwrvgnd_1
XFILLER_0_32_251 VGND VGND VPWR VPWR sky130_fd_sc_hd__fill_1
Xclkbuf_0_S_AXI_ACLK S_AXI_ACLK VGND VGND VPWR VPWR clknet_0_S_AXI_ACLK sky130_fd_sc_hd__clkbuf_16
XFILLER_0_55_310 VPWR VGND VPWR VGND sky130_ef_sc_hd__decap_12
X_1981_ _1667_ RX.rx_shifter\[10\] _1672_ uart_rdr\[10\] VGND VGND VPWR VPWR _1673_
+ sky130_fd_sc_hd__a22o_1
XFILLER_0_23_33 VGND VGND VPWR VPWR sky130_fd_sc_hd__fill_1
XFILLER_0_23_66 VGND VGND VPWR VPWR sky130_fd_sc_hd__fill_2
X_3651_ clknet_leaf_11_S_AXI_ACLK _0216_ VGND VGND VPWR VPWR RX.uart_cpb\[9\] sky130_fd_sc_hd__dfxtp_1
X_2533_ _0704_ _0714_ _0721_ VGND VGND VPWR VPWR _0722_ sky130_fd_sc_hd__and3_2
XFILLER_0_15_229 VGND VGND VPWR VPWR sky130_fd_sc_hd__fill_1
X_3582_ clknet_leaf_18_S_AXI_ACLK _0147_ net150 VGND VGND VPWR VPWR RX.baud_cnt\[15\]
+ sky130_fd_sc_hd__dfrtp_1
X_2602_ TX.baud_counter\[20\] _0783_ _0790_ TX.baud_counter\[19\] VGND VGND VPWR VPWR
+ _0791_ sky130_fd_sc_hd__o22a_1
X_2395_ _0574_ _0577_ _0578_ _0583_ VGND VGND VPWR VPWR _0584_ sky130_fd_sc_hd__a31o_1
X_2464_ _0651_ _0652_ VGND VGND VPWR VPWR _0653_ sky130_fd_sc_hd__nand2_1
XFILLER_0_3_65 VGND VGND VPWR VPWR sky130_fd_sc_hd__fill_2
X_3016_ _1159_ _1180_ _1182_ _1154_ RX.baud_cnt\[8\] VGND VGND VPWR VPWR _0140_ sky130_fd_sc_hd__a32o_1
Xfanout153 net154 VGND VGND VPWR VPWR net153 sky130_fd_sc_hd__buf_2
X_2180_ TX.baud_counter\[10\] _0386_ _0390_ TX.baud_counter\[11\] VGND VGND VPWR VPWR
+ _0391_ sky130_fd_sc_hd__a22o_1
XFILLER_0_34_76 VGND VGND VPWR VPWR sky130_fd_sc_hd__decap_4
XFILLER_0_43_302 VGND VGND VPWR VPWR sky130_fd_sc_hd__fill_2
X_1895_ _1571_ net284 _1600_ _1608_ VGND VGND VPWR VPWR _0028_ sky130_fd_sc_hd__o211a_1
X_3634_ clknet_leaf_0_S_AXI_ACLK _0199_ VGND VGND VPWR VPWR RX.uart_cpb\[24\] sky130_fd_sc_hd__dfxtp_2
X_1964_ _1646_ RX.rx_shifter\[5\] _1649_ uart_rdr\[5\] VGND VGND VPWR VPWR _1661_
+ sky130_fd_sc_hd__a22o_1
X_3703_ clknet_leaf_12_S_AXI_ACLK _0268_ net157 VGND VGND VPWR VPWR TX.data_latch\[2\]
+ sky130_fd_sc_hd__dfrtp_1
X_3496_ clknet_leaf_3_S_AXI_ACLK _0061_ VGND VGND VPWR VPWR uart_rdr\[21\] sky130_fd_sc_hd__dfxtp_1
X_3565_ clknet_leaf_4_S_AXI_ACLK _0130_ net159 VGND VGND VPWR VPWR RX.state\[0\] sky130_fd_sc_hd__dfrtp_4
X_2516_ RX.uart_cpb\[25\] RX.uart_cpb\[24\] VGND VGND VPWR VPWR _0705_ sky130_fd_sc_hd__or2_1
X_2447_ _0523_ _0524_ _0576_ VGND VGND VPWR VPWR _0636_ sky130_fd_sc_hd__o21a_1
XFILLER_0_45_3 VGND VGND VPWR VPWR sky130_fd_sc_hd__fill_1
X_2378_ _0560_ _0562_ _0566_ VGND VGND VPWR VPWR _0567_ sky130_fd_sc_hd__a21o_1
Xhold9 net127 VGND VGND VPWR VPWR net176 sky130_fd_sc_hd__dlygate4sd3_1
XFILLER_0_52_187 VGND VGND VPWR VPWR sky130_fd_sc_hd__fill_1
X_2301_ net259 _0497_ VGND VGND VPWR VPWR _0498_ sky130_fd_sc_hd__or2_1
X_3350_ TX.baud_counter\[18\] _1401_ VGND VGND VPWR VPWR _1405_ sky130_fd_sc_hd__and2_1
X_2232_ _0432_ _0442_ VGND VGND VPWR VPWR _0443_ sky130_fd_sc_hd__or2_2
X_3281_ _1352_ VGND VGND VPWR VPWR _1353_ sky130_fd_sc_hd__clkbuf_4
X_2163_ TX.baud_counter\[5\] _0358_ _0360_ _0371_ _0373_ VGND VGND VPWR VPWR _0374_
+ sky130_fd_sc_hd__o221a_1
XFILLER_0_0_88 VGND VGND VPWR VPWR sky130_fd_sc_hd__fill_2
X_2094_ net292 _0310_ VGND VGND VPWR VPWR _0317_ sky130_fd_sc_hd__or2_1
X_3617_ clknet_leaf_8_S_AXI_ACLK _0182_ net161 VGND VGND VPWR VPWR RX.rx_shifter\[15\]
+ sky130_fd_sc_hd__dfrtp_1
X_1878_ RX.uart_cpb\[17\] _1578_ _1593_ _1594_ VGND VGND VPWR VPWR _1595_ sky130_fd_sc_hd__a211o_1
X_1947_ _1648_ VGND VGND VPWR VPWR _1649_ sky130_fd_sc_hd__clkbuf_4
XFILLER_0_28_162 VGND VGND VPWR VPWR sky130_fd_sc_hd__fill_2
X_2996_ _0922_ _1166_ VGND VGND VPWR VPWR _1168_ sky130_fd_sc_hd__nand2_1
XFILLER_0_3_262 VGND VGND VPWR VPWR sky130_fd_sc_hd__fill_1
XFILLER_0_9_97 VGND VGND VPWR VPWR sky130_fd_sc_hd__fill_1
X_3548_ clknet_leaf_6_S_AXI_ACLK _0113_ VGND VGND VPWR VPWR TX.uart_tdr\[11\] sky130_fd_sc_hd__dfxtp_1
X_3479_ clknet_leaf_10_S_AXI_ACLK _0044_ VGND VGND VPWR VPWR uart_rdr\[4\] sky130_fd_sc_hd__dfxtp_1
XFILLER_0_34_132 VGND VGND VPWR VPWR sky130_fd_sc_hd__decap_8
X_2850_ _1557_ _1026_ _1014_ _1553_ VGND VGND VPWR VPWR _1027_ sky130_fd_sc_hd__a22o_1
XFILLER_0_40_124 VGND VGND VPWR VPWR sky130_fd_sc_hd__fill_1
X_1732_ net57 _1473_ VGND VGND VPWR VPWR _1474_ sky130_fd_sc_hd__nand2_1
X_2781_ RX.baud_cnt\[25\] _0434_ _0439_ RX.baud_cnt\[26\] VGND VGND VPWR VPWR _0958_
+ sky130_fd_sc_hd__a22o_1
X_1801_ uart_cfg\[2\] _1518_ _1520_ _1532_ VGND VGND VPWR VPWR _1533_ sky130_fd_sc_hd__a22o_1
X_3402_ TX.data_latch_next\[1\] net307 _1440_ VGND VGND VPWR VPWR _1442_ sky130_fd_sc_hd__mux2_1
X_3333_ TX.baud_counter\[13\] TX.baud_counter\[12\] _1385_ TX.baud_counter\[14\] VGND
+ VGND VPWR VPWR _1392_ sky130_fd_sc_hd__a31o_1
X_3264_ TX.state\[1\] _0471_ _0468_ VGND VGND VPWR VPWR _1340_ sky130_fd_sc_hd__a21boi_1
XFILLER_0_56_85 VGND VGND VPWR VPWR sky130_fd_sc_hd__fill_2
X_3195_ net90 _1292_ _1298_ _0890_ VGND VGND VPWR VPWR _0203_ sky130_fd_sc_hd__o211a_1
X_2146_ _1541_ _0334_ _1545_ VGND VGND VPWR VPWR _0357_ sky130_fd_sc_hd__o21ai_1
X_2077_ _1553_ _0291_ VGND VGND VPWR VPWR _0305_ sky130_fd_sc_hd__or2_1
X_2215_ TX.baud_counter\[21\] _0351_ _0355_ _0424_ _0425_ VGND VGND VPWR VPWR _0426_
+ sky130_fd_sc_hd__o221a_1
X_2979_ _1150_ _1147_ _1154_ VGND VGND VPWR VPWR _0131_ sky130_fd_sc_hd__a21oi_1
Xuart_top_167 VGND VGND VPWR VPWR uart_top_167/HI S_AXI_RRESP[1] sky130_fd_sc_hd__conb_1
X_2000_ _1667_ RX.rx_shifter\[16\] _1672_ uart_rdr\[16\] VGND VGND VPWR VPWR _1686_
+ sky130_fd_sc_hd__a22o_1
X_2833_ _0428_ _0895_ _0897_ _0348_ _0997_ VGND VGND VPWR VPWR _1010_ sky130_fd_sc_hd__o221ai_1
X_2902_ RX.baud_cnt\[11\] _0840_ _1078_ VGND VGND VPWR VPWR _1079_ sky130_fd_sc_hd__o21ai_1
X_2695_ _0879_ _0881_ _1486_ VGND VGND VPWR VPWR _0120_ sky130_fd_sc_hd__o21a_1
XFILLER_0_6_21 VGND VGND VPWR VPWR sky130_fd_sc_hd__decap_6
XFILLER_0_13_113 VPWR VGND VPWR VGND sky130_ef_sc_hd__decap_12
X_2764_ RX.baud_cnt\[22\] _0347_ _0907_ VGND VGND VPWR VPWR _0941_ sky130_fd_sc_hd__o21ai_1
X_3247_ net86 _1328_ _1330_ _1322_ VGND VGND VPWR VPWR _0223_ sky130_fd_sc_hd__o211a_1
XTAP_396 VGND VPWR sky130_fd_sc_hd__tapvpwrvgnd_1
XTAP_385 VGND VPWR sky130_fd_sc_hd__tapvpwrvgnd_1
XTAP_374 VGND VPWR sky130_fd_sc_hd__tapvpwrvgnd_1
XTAP_363 VGND VPWR sky130_fd_sc_hd__tapvpwrvgnd_1
XTAP_352 VGND VPWR sky130_fd_sc_hd__tapvpwrvgnd_1
XTAP_341 VGND VPWR sky130_fd_sc_hd__tapvpwrvgnd_1
XTAP_330 VGND VPWR sky130_fd_sc_hd__tapvpwrvgnd_1
X_3316_ _1353_ _1379_ VGND VGND VPWR VPWR _1380_ sky130_fd_sc_hd__nor2_1
X_3178_ net219 VGND VGND VPWR VPWR _1288_ sky130_fd_sc_hd__clkbuf_1
XPHY_69 VGND VGND VPWR VPWR sky130_fd_sc_hd__decap_3
XPHY_58 VGND VGND VPWR VPWR sky130_fd_sc_hd__decap_3
X_2129_ RX.uart_cpb\[15\] RX.uart_cpb\[14\] _0338_ _0339_ VGND VGND VPWR VPWR _0340_
+ sky130_fd_sc_hd__or4_1
XPHY_47 VGND VGND VPWR VPWR sky130_fd_sc_hd__decap_3
XPHY_14 VGND VGND VPWR VPWR sky130_fd_sc_hd__decap_3
XPHY_25 VGND VGND VPWR VPWR sky130_fd_sc_hd__decap_3
XPHY_36 VGND VGND VPWR VPWR sky130_fd_sc_hd__decap_3
XFILLER_0_12_13 VGND VGND VPWR VPWR sky130_fd_sc_hd__fill_1
Xoutput119 net119 VGND VGND VPWR VPWR S_AXI_RDATA[17] sky130_fd_sc_hd__clkbuf_4
Xoutput108 net108 VGND VGND VPWR VPWR S_AXI_ARREADY sky130_fd_sc_hd__clkbuf_4
X_2480_ _0665_ _0668_ VGND VGND VPWR VPWR _0669_ sky130_fd_sc_hd__nor2_1
XFILLER_0_37_43 VGND VGND VPWR VPWR sky130_fd_sc_hd__fill_1
XFILLER_0_37_10 VGND VGND VPWR VPWR sky130_fd_sc_hd__decap_3
X_3101_ RX.bit_idx\[1\] _0970_ VGND VGND VPWR VPWR _1243_ sky130_fd_sc_hd__nand2_1
XFILLER_0_53_42 VGND VGND VPWR VPWR sky130_fd_sc_hd__fill_1
X_3032_ _1158_ VGND VGND VPWR VPWR _1194_ sky130_fd_sc_hd__clkbuf_4
X_2816_ _0723_ RX.baud_cnt\[24\] _0989_ RX.uart_cpb\[29\] _0992_ VGND VGND VPWR VPWR
+ _0993_ sky130_fd_sc_hd__a221o_1
XFILLER_0_5_198 VGND VGND VPWR VPWR sky130_fd_sc_hd__fill_1
X_2747_ RX.baud_cnt\[1\] _0363_ VGND VGND VPWR VPWR _0924_ sky130_fd_sc_hd__or2_1
X_2678_ TX.baud_counter\[26\] _0861_ _0866_ TX.baud_counter\[27\] VGND VGND VPWR VPWR
+ _0867_ sky130_fd_sc_hd__a22o_1
XTAP_160 VGND VPWR sky130_fd_sc_hd__tapvpwrvgnd_1
XTAP_171 VGND VPWR sky130_fd_sc_hd__tapvpwrvgnd_1
XTAP_182 VGND VPWR sky130_fd_sc_hd__tapvpwrvgnd_1
XTAP_193 VGND VPWR sky130_fd_sc_hd__tapvpwrvgnd_1
XFILLER_0_24_208 VGND VGND VPWR VPWR sky130_fd_sc_hd__fill_1
XFILLER_0_55_322 VPWR VGND VPWR VGND sky130_ef_sc_hd__decap_12
X_1980_ _1648_ VGND VGND VPWR VPWR _1672_ sky130_fd_sc_hd__clkbuf_4
X_3650_ clknet_leaf_11_S_AXI_ACLK _0215_ VGND VGND VPWR VPWR RX.uart_cpb\[8\] sky130_fd_sc_hd__dfxtp_2
X_2532_ _0428_ _0313_ _0718_ _0719_ _0720_ VGND VGND VPWR VPWR _0721_ sky130_fd_sc_hd__o221a_1
X_2601_ _0690_ _0789_ VGND VGND VPWR VPWR _0790_ sky130_fd_sc_hd__nor2_1
X_2463_ _0511_ _0650_ _0576_ VGND VGND VPWR VPWR _0652_ sky130_fd_sc_hd__o21a_1
X_3581_ clknet_leaf_18_S_AXI_ACLK _0146_ net150 VGND VGND VPWR VPWR RX.baud_cnt\[14\]
+ sky130_fd_sc_hd__dfrtp_4
X_2394_ _0579_ _1526_ _0582_ _0348_ VGND VGND VPWR VPWR _0583_ sky130_fd_sc_hd__a22o_1
X_3015_ _1160_ _1181_ VGND VGND VPWR VPWR _1182_ sky130_fd_sc_hd__nor2_1
Xfanout154 net163 VGND VGND VPWR VPWR net154 sky130_fd_sc_hd__clkbuf_4
X_3633_ clknet_leaf_7_S_AXI_ACLK _0198_ net162 VGND VGND VPWR VPWR RX.rx_shifter\[31\]
+ sky130_fd_sc_hd__dfrtp_1
X_1894_ RX.uart_cpb\[20\] _1578_ _1606_ _1607_ VGND VGND VPWR VPWR _1608_ sky130_fd_sc_hd__a211o_1
X_3702_ clknet_leaf_13_S_AXI_ACLK _0267_ net157 VGND VGND VPWR VPWR TX.data_latch\[1\]
+ sky130_fd_sc_hd__dfrtp_1
X_1963_ _1660_ VGND VGND VPWR VPWR _0044_ sky130_fd_sc_hd__clkbuf_1
X_3495_ clknet_leaf_3_S_AXI_ACLK _0060_ VGND VGND VPWR VPWR uart_rdr\[20\] sky130_fd_sc_hd__dfxtp_1
X_3564_ clknet_leaf_9_S_AXI_ACLK _0129_ VGND VGND VPWR VPWR net108 sky130_fd_sc_hd__dfxtp_1
X_2515_ _0703_ VGND VGND VPWR VPWR _0704_ sky130_fd_sc_hd__clkbuf_2
X_2446_ _0588_ _0632_ _0633_ _0634_ VGND VGND VPWR VPWR _0635_ sky130_fd_sc_hd__o31a_1
XFILLER_0_11_200 VGND VGND VPWR VPWR sky130_fd_sc_hd__fill_1
X_2377_ _0563_ _0564_ _0565_ VGND VGND VPWR VPWR _0566_ sky130_fd_sc_hd__or3b_1
XFILLER_0_46_141 VGND VGND VPWR VPWR sky130_fd_sc_hd__fill_1
XFILLER_0_6_271 VGND VGND VPWR VPWR sky130_fd_sc_hd__fill_1
X_2300_ _1479_ _0494_ VGND VGND VPWR VPWR _0497_ sky130_fd_sc_hd__nor2_2
X_2231_ RX.uart_cpb\[27\] _1625_ VGND VGND VPWR VPWR _0442_ sky130_fd_sc_hd__or2_1
XFILLER_0_29_66 VGND VGND VPWR VPWR sky130_fd_sc_hd__fill_1
XFILLER_0_29_44 VPWR VGND VPWR VGND sky130_ef_sc_hd__decap_12
XFILLER_0_29_33 VGND VGND VPWR VPWR sky130_fd_sc_hd__fill_2
X_3280_ TX.state\[1\] TX.state\[0\] VGND VGND VPWR VPWR _1352_ sky130_fd_sc_hd__nor2_4
X_2093_ net95 _0309_ _0316_ _0296_ VGND VGND VPWR VPWR _0083_ sky130_fd_sc_hd__o211a_1
X_2162_ TX.baud_counter\[6\] _0372_ VGND VGND VPWR VPWR _0373_ sky130_fd_sc_hd__or2_1
XFILLER_0_28_141 VGND VGND VPWR VPWR sky130_fd_sc_hd__fill_2
X_2995_ _1159_ _1165_ _1167_ _1154_ net288 VGND VGND VPWR VPWR _0134_ sky130_fd_sc_hd__a32o_1
XFILLER_0_0_34 VGND VGND VPWR VPWR sky130_fd_sc_hd__fill_2
X_1877_ uart_rdr\[17\] _1580_ _1590_ VGND VGND VPWR VPWR _1594_ sky130_fd_sc_hd__a21bo_1
X_3616_ clknet_leaf_8_S_AXI_ACLK _0181_ net161 VGND VGND VPWR VPWR RX.rx_shifter\[14\]
+ sky130_fd_sc_hd__dfrtp_1
X_1946_ RX.done_reg _1647_ VGND VGND VPWR VPWR _1648_ sky130_fd_sc_hd__nor2_2
X_3547_ clknet_leaf_6_S_AXI_ACLK _0112_ VGND VGND VPWR VPWR TX.uart_tdr\[10\] sky130_fd_sc_hd__dfxtp_1
X_3478_ clknet_leaf_10_S_AXI_ACLK _0043_ VGND VGND VPWR VPWR uart_rdr\[3\] sky130_fd_sc_hd__dfxtp_1
X_2429_ RX.uart_cpb\[2\] RX.uart_cpb\[0\] VGND VGND VPWR VPWR _0618_ sky130_fd_sc_hd__or2_1
X_1800_ RX.uart_cpb\[2\] VGND VGND VPWR VPWR _1532_ sky130_fd_sc_hd__clkbuf_4
X_1731_ net61 _1471_ _1472_ VGND VGND VPWR VPWR _1473_ sky130_fd_sc_hd__nor3_1
X_3401_ net299 VGND VGND VPWR VPWR _0266_ sky130_fd_sc_hd__clkbuf_1
X_2780_ RX.baud_cnt\[24\] _0430_ _0948_ _0955_ _0956_ VGND VGND VPWR VPWR _0957_ sky130_fd_sc_hd__o221a_1
X_3194_ _0455_ _1291_ VGND VGND VPWR VPWR _1298_ sky130_fd_sc_hd__nand2_1
X_3332_ TX.baud_counter\[13\] _1355_ _1350_ _1391_ VGND VGND VPWR VPWR _0247_ sky130_fd_sc_hd__a22o_1
X_3263_ _1465_ _1463_ VGND VGND VPWR VPWR _1339_ sky130_fd_sc_hd__and2_1
X_2214_ TX.baud_counter\[22\] _0347_ VGND VGND VPWR VPWR _0425_ sky130_fd_sc_hd__or2_1
X_2145_ _1545_ _1541_ _0334_ VGND VGND VPWR VPWR _0356_ sky130_fd_sc_hd__or3_2
X_2076_ net98 _0291_ _0304_ VGND VGND VPWR VPWR _0078_ sky130_fd_sc_hd__a21o_1
XFILLER_0_22_6 VGND VGND VPWR VPWR sky130_fd_sc_hd__decap_4
X_1929_ _1609_ net175 _1600_ _1634_ VGND VGND VPWR VPWR _0036_ sky130_fd_sc_hd__o211a_1
X_2978_ _1153_ VGND VGND VPWR VPWR _1154_ sky130_fd_sc_hd__clkbuf_4
XFILLER_0_8_333 VGND VGND VPWR VPWR sky130_fd_sc_hd__fill_2
XFILLER_0_16_133 VGND VGND VPWR VPWR sky130_fd_sc_hd__decap_6
XFILLER_0_31_147 VGND VGND VPWR VPWR sky130_fd_sc_hd__decap_3
XFILLER_0_22_103 VGND VGND VPWR VPWR sky130_fd_sc_hd__fill_1
Xhold90 TX.bit_index\[1\] VGND VGND VPWR VPWR net257 sky130_fd_sc_hd__dlygate4sd3_1
X_2832_ _0428_ _0895_ _0897_ _0348_ _1008_ VGND VGND VPWR VPWR _1009_ sky130_fd_sc_hd__o221a_1
XFILLER_0_5_325 VGND VGND VPWR VPWR sky130_fd_sc_hd__decap_4
X_2763_ _0895_ _0349_ VGND VGND VPWR VPWR _0940_ sky130_fd_sc_hd__nor2_1
X_2901_ RX.baud_cnt\[10\] _0836_ VGND VGND VPWR VPWR _1078_ sky130_fd_sc_hd__or2_1
XFILLER_0_13_125 VGND VGND VPWR VPWR sky130_fd_sc_hd__decap_4
X_2694_ _0880_ _0876_ net230 VGND VGND VPWR VPWR _0881_ sky130_fd_sc_hd__o21a_1
X_3177_ _1287_ VGND VGND VPWR VPWR _0196_ sky130_fd_sc_hd__clkbuf_1
X_3246_ net317 _1329_ VGND VGND VPWR VPWR _1330_ sky130_fd_sc_hd__or2_1
XTAP_397 VGND VPWR sky130_fd_sc_hd__tapvpwrvgnd_1
XTAP_386 VGND VPWR sky130_fd_sc_hd__tapvpwrvgnd_1
XTAP_375 VGND VPWR sky130_fd_sc_hd__tapvpwrvgnd_1
XTAP_364 VGND VPWR sky130_fd_sc_hd__tapvpwrvgnd_1
XTAP_353 VGND VPWR sky130_fd_sc_hd__tapvpwrvgnd_1
XTAP_342 VGND VPWR sky130_fd_sc_hd__tapvpwrvgnd_1
XTAP_331 VGND VPWR sky130_fd_sc_hd__tapvpwrvgnd_1
XTAP_320 VGND VPWR sky130_fd_sc_hd__tapvpwrvgnd_1
X_3315_ TX.baud_counter\[9\] _1376_ VGND VGND VPWR VPWR _1379_ sky130_fd_sc_hd__and2_1
XFILLER_0_20_3 VGND VGND VPWR VPWR sky130_fd_sc_hd__decap_8
XPHY_59 VGND VGND VPWR VPWR sky130_fd_sc_hd__decap_3
X_2128_ RX.uart_cpb\[13\] RX.uart_cpb\[12\] VGND VGND VPWR VPWR _0339_ sky130_fd_sc_hd__or2_1
XPHY_48 VGND VGND VPWR VPWR sky130_fd_sc_hd__decap_3
X_2059_ RX.uart_cpb\[1\] VGND VGND VPWR VPWR _0293_ sky130_fd_sc_hd__inv_2
XPHY_15 VGND VGND VPWR VPWR sky130_fd_sc_hd__decap_3
XPHY_26 VGND VGND VPWR VPWR sky130_fd_sc_hd__decap_3
XPHY_37 VGND VGND VPWR VPWR sky130_fd_sc_hd__decap_3
XFILLER_0_29_291 VGND VGND VPWR VPWR sky130_fd_sc_hd__fill_2
XFILLER_0_50_231 VGND VGND VPWR VPWR sky130_fd_sc_hd__decap_4
Xoutput109 net109 VGND VGND VPWR VPWR S_AXI_AWREADY sky130_fd_sc_hd__clkbuf_4
X_3100_ RX.bit_idx\[1\] RX.bit_idx\[0\] VGND VGND VPWR VPWR _1242_ sky130_fd_sc_hd__or2_1
X_3031_ _1159_ _1191_ _1193_ _1186_ RX.baud_cnt\[12\] VGND VGND VPWR VPWR _0144_ sky130_fd_sc_hd__a32o_1
X_2815_ _0990_ _0991_ _0986_ VGND VGND VPWR VPWR _0992_ sky130_fd_sc_hd__or3b_1
XFILLER_0_26_250 VGND VGND VPWR VPWR sky130_fd_sc_hd__fill_2
XFILLER_0_5_111 VGND VGND VPWR VPWR sky130_fd_sc_hd__fill_1
X_2746_ _0922_ _0362_ _0367_ RX.baud_cnt\[2\] VGND VGND VPWR VPWR _0923_ sky130_fd_sc_hd__o22a_1
X_2677_ _0738_ _0865_ VGND VGND VPWR VPWR _0866_ sky130_fd_sc_hd__nor2_2
XTAP_150 VGND VPWR sky130_fd_sc_hd__tapvpwrvgnd_1
X_3229_ net101 _1318_ _1319_ _1302_ VGND VGND VPWR VPWR _0216_ sky130_fd_sc_hd__o211a_1
XTAP_161 VGND VPWR sky130_fd_sc_hd__tapvpwrvgnd_1
XTAP_172 VGND VPWR sky130_fd_sc_hd__tapvpwrvgnd_1
XTAP_183 VGND VPWR sky130_fd_sc_hd__tapvpwrvgnd_1
XTAP_194 VGND VPWR sky130_fd_sc_hd__tapvpwrvgnd_1
XFILLER_0_55_334 VGND VGND VPWR VPWR sky130_fd_sc_hd__fill_2
X_2600_ _0676_ _0688_ _0592_ VGND VGND VPWR VPWR _0789_ sky130_fd_sc_hd__a21oi_1
X_3580_ clknet_leaf_17_S_AXI_ACLK _0145_ net154 VGND VGND VPWR VPWR RX.baud_cnt\[13\]
+ sky130_fd_sc_hd__dfrtp_1
XFILLER_0_23_57 VGND VGND VPWR VPWR sky130_fd_sc_hd__decap_4
XFILLER_0_54_9 VPWR VGND VPWR VGND sky130_ef_sc_hd__decap_12
X_2531_ RX.uart_cpb\[25\] _0582_ VGND VGND VPWR VPWR _0720_ sky130_fd_sc_hd__nand2_1
X_2393_ _0581_ VGND VGND VPWR VPWR _0582_ sky130_fd_sc_hd__clkbuf_4
X_2462_ _0511_ _0650_ VGND VGND VPWR VPWR _0651_ sky130_fd_sc_hd__nand2_1
XFILLER_0_3_45 VGND VGND VPWR VPWR sky130_fd_sc_hd__fill_1
X_3014_ RX.baud_cnt\[8\] RX.baud_cnt\[7\] _1177_ VGND VGND VPWR VPWR _1181_ sky130_fd_sc_hd__and3_1
X_2729_ _0901_ _0903_ _0905_ VGND VGND VPWR VPWR _0906_ sky130_fd_sc_hd__o21ba_1
Xfanout155 net156 VGND VGND VPWR VPWR net155 sky130_fd_sc_hd__clkbuf_4
XFILLER_0_52_326 VPWR VGND VPWR VGND sky130_ef_sc_hd__decap_12
XFILLER_0_37_334 VGND VGND VPWR VPWR sky130_fd_sc_hd__fill_2
XFILLER_0_37_323 VGND VGND VPWR VPWR sky130_fd_sc_hd__fill_2
Xclkbuf_leaf_13_S_AXI_ACLK clknet_1_1__leaf_S_AXI_ACLK VGND VGND VPWR VPWR clknet_leaf_13_S_AXI_ACLK
+ sky130_fd_sc_hd__clkbuf_16
XFILLER_0_55_120 VGND VGND VPWR VPWR sky130_fd_sc_hd__fill_1
X_1962_ _1654_ _1659_ VGND VGND VPWR VPWR _1660_ sky130_fd_sc_hd__and2_1
X_1893_ uart_rdr\[20\] _1580_ _1590_ VGND VGND VPWR VPWR _1607_ sky130_fd_sc_hd__a21bo_1
X_3632_ clknet_leaf_3_S_AXI_ACLK _0197_ net156 VGND VGND VPWR VPWR RX.rx_shifter\[30\]
+ sky130_fd_sc_hd__dfrtp_1
X_3563_ clknet_leaf_2_S_AXI_ACLK _0128_ VGND VGND VPWR VPWR RX.uart_stp\[23\] sky130_fd_sc_hd__dfxtp_1
X_3701_ clknet_leaf_13_S_AXI_ACLK _0266_ net157 VGND VGND VPWR VPWR TX.data_latch\[0\]
+ sky130_fd_sc_hd__dfrtp_1
X_3494_ clknet_leaf_7_S_AXI_ACLK _0059_ VGND VGND VPWR VPWR uart_rdr\[19\] sky130_fd_sc_hd__dfxtp_1
X_2376_ RX.uart_cpb\[22\] RX.uart_cpb\[21\] VGND VGND VPWR VPWR _0565_ sky130_fd_sc_hd__xor2_1
X_2514_ _0584_ _0690_ _0702_ VGND VGND VPWR VPWR _0703_ sky130_fd_sc_hd__and3_1
X_2445_ _1525_ _1532_ _0581_ _1535_ VGND VGND VPWR VPWR _0634_ sky130_fd_sc_hd__a22oi_1
XFILLER_0_46_197 VGND VGND VPWR VPWR sky130_fd_sc_hd__fill_1
XFILLER_0_19_334 VGND VGND VPWR VPWR sky130_fd_sc_hd__fill_2
XFILLER_0_37_120 VGND VGND VPWR VPWR sky130_fd_sc_hd__fill_2
XFILLER_0_25_326 VGND VGND VPWR VPWR sky130_fd_sc_hd__fill_1
XFILLER_0_20_47 VGND VGND VPWR VPWR sky130_fd_sc_hd__fill_1
X_2230_ RX.uart_cpb\[27\] VGND VGND VPWR VPWR _0441_ sky130_fd_sc_hd__inv_2
X_2092_ net210 _0310_ VGND VGND VPWR VPWR _0316_ sky130_fd_sc_hd__or2_1
X_2161_ _0303_ _0356_ VGND VGND VPWR VPWR _0372_ sky130_fd_sc_hd__xnor2_2
X_1945_ net108 net34 _1512_ VGND VGND VPWR VPWR _1647_ sky130_fd_sc_hd__and3_1
XFILLER_0_28_197 VGND VGND VPWR VPWR sky130_fd_sc_hd__fill_1
X_2994_ _1160_ _1166_ VGND VGND VPWR VPWR _1167_ sky130_fd_sc_hd__nor2_1
XFILLER_0_0_57 VGND VGND VPWR VPWR sky130_fd_sc_hd__fill_2
X_3615_ clknet_leaf_7_S_AXI_ACLK _0180_ net159 VGND VGND VPWR VPWR RX.rx_shifter\[13\]
+ sky130_fd_sc_hd__dfrtp_1
X_1876_ TX.uart_tdr\[17\] _1566_ _1567_ RX.uart_stp\[17\] VGND VGND VPWR VPWR _1593_
+ sky130_fd_sc_hd__a22o_1
X_3546_ clknet_leaf_5_S_AXI_ACLK _0111_ VGND VGND VPWR VPWR TX.uart_tdr\[9\] sky130_fd_sc_hd__dfxtp_1
XFILLER_0_3_242 VGND VGND VPWR VPWR sky130_fd_sc_hd__fill_1
X_3477_ clknet_leaf_9_S_AXI_ACLK _0042_ VGND VGND VPWR VPWR uart_rdr\[2\] sky130_fd_sc_hd__dfxtp_1
X_2359_ _0534_ _0537_ _0547_ VGND VGND VPWR VPWR _0548_ sky130_fd_sc_hd__a21o_1
X_2428_ _0576_ _0614_ _0615_ _0616_ VGND VGND VPWR VPWR _0617_ sky130_fd_sc_hd__a31oi_4
XFILLER_0_34_167 VGND VGND VPWR VPWR sky130_fd_sc_hd__decap_4
XFILLER_0_31_57 VGND VGND VPWR VPWR sky130_fd_sc_hd__fill_1
X_1730_ net62 net64 net63 VGND VGND VPWR VPWR _1472_ sky130_fd_sc_hd__or3_2
X_3400_ TX.data_latch_next\[0\] net298 _1440_ VGND VGND VPWR VPWR _1441_ sky130_fd_sc_hd__mux2_1
X_3331_ TX.baud_counter\[13\] _1388_ _1390_ VGND VGND VPWR VPWR _1391_ sky130_fd_sc_hd__o21a_1
Xclkbuf_leaf_3_S_AXI_ACLK clknet_1_0__leaf_S_AXI_ACLK VGND VGND VPWR VPWR clknet_leaf_3_S_AXI_ACLK
+ sky130_fd_sc_hd__clkbuf_16
X_3262_ net94 _1328_ _1338_ _1336_ VGND VGND VPWR VPWR _0230_ sky130_fd_sc_hd__o211a_1
X_3193_ net89 _1292_ _1297_ _0890_ VGND VGND VPWR VPWR _0202_ sky130_fd_sc_hd__o211a_1
X_2213_ _0418_ _0422_ _0354_ TX.baud_counter\[20\] _0423_ VGND VGND VPWR VPWR _0424_
+ sky130_fd_sc_hd__o221a_1
X_2144_ TX.baud_counter\[20\] _0354_ _0351_ TX.baud_counter\[21\] VGND VGND VPWR VPWR
+ _0355_ sky130_fd_sc_hd__a22o_1
XFILLER_0_48_248 VGND VGND VPWR VPWR sky130_fd_sc_hd__decap_4
XFILLER_0_48_204 VGND VGND VPWR VPWR sky130_fd_sc_hd__fill_1
X_2075_ _0303_ _0291_ _1635_ VGND VGND VPWR VPWR _0304_ sky130_fd_sc_hd__o21ai_1
X_1859_ _1512_ VGND VGND VPWR VPWR _1580_ sky130_fd_sc_hd__clkbuf_4
X_1928_ RX.uart_cpb\[28\] _1521_ _1632_ _1633_ VGND VGND VPWR VPWR _1634_ sky130_fd_sc_hd__a211o_1
X_2977_ _1152_ VGND VGND VPWR VPWR _1153_ sky130_fd_sc_hd__clkbuf_4
XFILLER_0_6_9 VPWR VGND VPWR VGND sky130_ef_sc_hd__decap_12
X_3529_ clknet_leaf_14_S_AXI_ACLK _0094_ VGND VGND VPWR VPWR TX.data_latch_next\[6\]
+ sky130_fd_sc_hd__dfxtp_1
XFILLER_0_22_126 VGND VGND VPWR VPWR sky130_fd_sc_hd__fill_2
Xhold80 TX.uart_tdr\[22\] VGND VGND VPWR VPWR net247 sky130_fd_sc_hd__dlygate4sd3_1
Xhold91 TX.uart_tdr\[16\] VGND VGND VPWR VPWR net258 sky130_fd_sc_hd__dlygate4sd3_1
X_2900_ RX.baud_cnt\[12\] _0803_ _0840_ RX.baud_cnt\[11\] VGND VGND VPWR VPWR _1077_
+ sky130_fd_sc_hd__a22o_1
X_2831_ _0997_ _1006_ _1007_ VGND VGND VPWR VPWR _1008_ sky130_fd_sc_hd__a21o_1
X_2762_ RX.baud_cnt\[15\] _0406_ VGND VGND VPWR VPWR _0939_ sky130_fd_sc_hd__nand2_1
XTAP_332 VGND VPWR sky130_fd_sc_hd__tapvpwrvgnd_1
XTAP_321 VGND VPWR sky130_fd_sc_hd__tapvpwrvgnd_1
XTAP_310 VGND VPWR sky130_fd_sc_hd__tapvpwrvgnd_1
X_2693_ net70 VGND VGND VPWR VPWR _0880_ sky130_fd_sc_hd__inv_2
X_3314_ TX.baud_counter\[9\] _1376_ VGND VGND VPWR VPWR _1378_ sky130_fd_sc_hd__or2_1
X_3176_ net262 VGND VGND VPWR VPWR _1287_ sky130_fd_sc_hd__clkbuf_1
XTAP_398 VGND VPWR sky130_fd_sc_hd__tapvpwrvgnd_1
XTAP_387 VGND VPWR sky130_fd_sc_hd__tapvpwrvgnd_1
XTAP_376 VGND VPWR sky130_fd_sc_hd__tapvpwrvgnd_1
XTAP_365 VGND VPWR sky130_fd_sc_hd__tapvpwrvgnd_1
XTAP_354 VGND VPWR sky130_fd_sc_hd__tapvpwrvgnd_1
XTAP_343 VGND VPWR sky130_fd_sc_hd__tapvpwrvgnd_1
X_3245_ _1480_ _0307_ VGND VGND VPWR VPWR _1329_ sky130_fd_sc_hd__nor2_2
X_2127_ _1562_ _1557_ _0336_ _0337_ VGND VGND VPWR VPWR _0338_ sky130_fd_sc_hd__or4_4
XFILLER_0_13_3 VGND VGND VPWR VPWR sky130_fd_sc_hd__decap_3
XPHY_49 VGND VGND VPWR VPWR sky130_fd_sc_hd__decap_3
XPHY_16 VGND VGND VPWR VPWR sky130_fd_sc_hd__decap_3
XPHY_27 VGND VGND VPWR VPWR sky130_fd_sc_hd__decap_3
XPHY_38 VGND VGND VPWR VPWR sky130_fd_sc_hd__decap_3
X_2058_ net70 _0290_ _0292_ _1486_ VGND VGND VPWR VPWR _0072_ sky130_fd_sc_hd__o211a_1
XFILLER_0_50_243 VGND VGND VPWR VPWR sky130_fd_sc_hd__fill_2
XFILLER_0_10_118 VGND VGND VPWR VPWR sky130_fd_sc_hd__fill_2
XFILLER_0_53_11 VGND VGND VPWR VPWR sky130_fd_sc_hd__fill_2
X_3030_ _0974_ _1192_ VGND VGND VPWR VPWR _1193_ sky130_fd_sc_hd__nor2_1
XFILLER_0_41_254 VGND VGND VPWR VPWR sky130_fd_sc_hd__fill_2
X_2676_ _0722_ _0732_ _0737_ VGND VGND VPWR VPWR _0865_ sky130_fd_sc_hd__a21oi_1
X_2814_ RX.baud_cnt\[31\] _0983_ _0982_ _0988_ VGND VGND VPWR VPWR _0991_ sky130_fd_sc_hd__or4_1
X_2745_ RX.baud_cnt\[3\] VGND VGND VPWR VPWR _0922_ sky130_fd_sc_hd__buf_2
XTAP_151 VGND VPWR sky130_fd_sc_hd__tapvpwrvgnd_1
XTAP_140 VGND VPWR sky130_fd_sc_hd__tapvpwrvgnd_1
XTAP_162 VGND VPWR sky130_fd_sc_hd__tapvpwrvgnd_1
XTAP_173 VGND VPWR sky130_fd_sc_hd__tapvpwrvgnd_1
XTAP_184 VGND VPWR sky130_fd_sc_hd__tapvpwrvgnd_1
X_3159_ _1278_ VGND VGND VPWR VPWR _0187_ sky130_fd_sc_hd__clkbuf_1
X_3228_ _0649_ _1318_ VGND VGND VPWR VPWR _1319_ sky130_fd_sc_hd__nand2_1
XTAP_195 VGND VPWR sky130_fd_sc_hd__tapvpwrvgnd_1
XFILLER_0_55_357 VGND VGND VPWR VPWR sky130_fd_sc_hd__decap_3
X_2530_ _0715_ _0716_ _0717_ _0589_ VGND VGND VPWR VPWR _0719_ sky130_fd_sc_hd__a31o_1
X_2461_ _0515_ _0530_ _0533_ _0536_ VGND VGND VPWR VPWR _0650_ sky130_fd_sc_hd__o31ai_1
X_2392_ _0580_ VGND VGND VPWR VPWR _0581_ sky130_fd_sc_hd__clkbuf_4
XFILLER_0_3_57 VGND VGND VPWR VPWR sky130_fd_sc_hd__fill_2
X_3013_ RX.baud_cnt\[7\] _1177_ RX.baud_cnt\[8\] VGND VGND VPWR VPWR _1180_ sky130_fd_sc_hd__a21o_1
XFILLER_0_14_232 VGND VGND VPWR VPWR sky130_fd_sc_hd__decap_4
X_2728_ RX.baud_cnt\[18\] _0416_ _0421_ _0904_ VGND VGND VPWR VPWR _0905_ sky130_fd_sc_hd__o22ai_1
X_2659_ TX.baud_counter\[14\] _0845_ VGND VGND VPWR VPWR _0848_ sky130_fd_sc_hd__or2_1
Xfanout156 net163 VGND VGND VPWR VPWR net156 sky130_fd_sc_hd__buf_2
XFILLER_0_52_338 VPWR VGND VPWR VGND sky130_ef_sc_hd__decap_12
XFILLER_0_9_281 VGND VGND VPWR VPWR sky130_fd_sc_hd__fill_1
XFILLER_0_20_224 VGND VGND VPWR VPWR sky130_fd_sc_hd__decap_4
XFILLER_0_18_36 VGND VGND VPWR VPWR sky130_fd_sc_hd__decap_6
XFILLER_0_18_58 VGND VGND VPWR VPWR sky130_fd_sc_hd__decap_3
X_1892_ TX.uart_tdr\[20\] _1604_ _1605_ RX.uart_stp\[20\] VGND VGND VPWR VPWR _1606_
+ sky130_fd_sc_hd__a22o_1
X_1961_ _1646_ RX.rx_shifter\[4\] _1649_ uart_rdr\[4\] VGND VGND VPWR VPWR _1659_
+ sky130_fd_sc_hd__a22o_1
X_3700_ clknet_leaf_18_S_AXI_ACLK _0265_ net152 VGND VGND VPWR VPWR TX.baud_counter\[31\]
+ sky130_fd_sc_hd__dfrtp_4
X_3493_ clknet_leaf_7_S_AXI_ACLK _0058_ VGND VGND VPWR VPWR uart_rdr\[18\] sky130_fd_sc_hd__dfxtp_1
X_3631_ clknet_leaf_2_S_AXI_ACLK _0196_ net155 VGND VGND VPWR VPWR RX.rx_shifter\[29\]
+ sky130_fd_sc_hd__dfrtp_1
X_3562_ clknet_leaf_1_S_AXI_ACLK _0127_ VGND VGND VPWR VPWR RX.uart_stp\[22\] sky130_fd_sc_hd__dfxtp_1
X_2513_ _0693_ _0699_ _0701_ VGND VGND VPWR VPWR _0702_ sky130_fd_sc_hd__and3_1
XFILLER_0_52_7 VPWR VGND VPWR VGND sky130_ef_sc_hd__decap_12
X_2375_ RX.uart_cpb\[21\] RX.uart_cpb\[20\] VGND VGND VPWR VPWR _0564_ sky130_fd_sc_hd__nor2_1
X_2444_ _0631_ _0625_ _0630_ _0519_ VGND VGND VPWR VPWR _0633_ sky130_fd_sc_hd__a211oi_1
XFILLER_0_6_251 VGND VGND VPWR VPWR sky130_fd_sc_hd__fill_1
XFILLER_0_37_132 VGND VGND VPWR VPWR sky130_fd_sc_hd__decap_3
X_2160_ TX.baud_counter\[3\] _0362_ _0368_ _0369_ _0370_ VGND VGND VPWR VPWR _0371_
+ sky130_fd_sc_hd__o221a_1
Xmax_cap1 _1504_ VGND VGND VPWR VPWR net331 sky130_fd_sc_hd__clkbuf_1
X_2091_ net92 _0309_ _0315_ _0296_ VGND VGND VPWR VPWR _0082_ sky130_fd_sc_hd__o211a_1
X_1875_ _1571_ net179 _1561_ _1592_ VGND VGND VPWR VPWR _0024_ sky130_fd_sc_hd__o211a_1
X_3614_ clknet_leaf_8_S_AXI_ACLK _0179_ net161 VGND VGND VPWR VPWR RX.rx_shifter\[12\]
+ sky130_fd_sc_hd__dfrtp_1
X_1944_ RX.done_reg VGND VGND VPWR VPWR _1646_ sky130_fd_sc_hd__buf_2
X_2993_ _1018_ _1162_ VGND VGND VPWR VPWR _1166_ sky130_fd_sc_hd__nor2_2
X_3476_ clknet_leaf_9_S_AXI_ACLK _0041_ VGND VGND VPWR VPWR uart_rdr\[1\] sky130_fd_sc_hd__dfxtp_1
X_3545_ clknet_leaf_5_S_AXI_ACLK _0110_ VGND VGND VPWR VPWR TX.uart_tdr\[8\] sky130_fd_sc_hd__dfxtp_1
X_2427_ _1525_ _1545_ _0581_ RX.uart_cpb\[6\] VGND VGND VPWR VPWR _0616_ sky130_fd_sc_hd__a22o_1
XFILLER_0_43_3 VGND VGND VPWR VPWR sky130_fd_sc_hd__fill_2
X_2289_ net191 _0484_ VGND VGND VPWR VPWR _0490_ sky130_fd_sc_hd__or2_1
X_2358_ _0540_ _0542_ _0543_ _0546_ VGND VGND VPWR VPWR _0547_ sky130_fd_sc_hd__or4_1
XFILLER_0_19_90 VGND VGND VPWR VPWR sky130_fd_sc_hd__fill_1
XFILLER_0_19_176 VGND VGND VPWR VPWR sky130_fd_sc_hd__decap_6
XFILLER_0_19_198 VGND VGND VPWR VPWR sky130_fd_sc_hd__decap_8
XFILLER_0_15_37 VGND VGND VPWR VPWR sky130_fd_sc_hd__fill_1
XFILLER_0_25_113 VGND VGND VPWR VPWR sky130_fd_sc_hd__fill_2
X_3330_ TX.baud_counter\[13\] _1388_ _1352_ VGND VGND VPWR VPWR _1390_ sky130_fd_sc_hd__a21oi_1
XFILLER_0_21_363 VGND VGND VPWR VPWR sky130_fd_sc_hd__fill_1
XFILLER_0_56_22 VGND VGND VPWR VPWR sky130_fd_sc_hd__fill_2
X_3261_ net243 _1329_ VGND VGND VPWR VPWR _1338_ sky130_fd_sc_hd__or2_1
X_3192_ _0441_ _1292_ VGND VGND VPWR VPWR _1297_ sky130_fd_sc_hd__nand2_1
X_2143_ _0352_ _0353_ VGND VGND VPWR VPWR _0354_ sky130_fd_sc_hd__xnor2_2
X_2212_ TX.baud_counter\[19\] _0421_ VGND VGND VPWR VPWR _0423_ sky130_fd_sc_hd__or2_1
X_2074_ RX.uart_cpb\[6\] VGND VGND VPWR VPWR _0303_ sky130_fd_sc_hd__inv_2
X_1858_ TX.uart_tdr\[13\] _1566_ _1567_ RX.uart_stp\[13\] VGND VGND VPWR VPWR _1579_
+ sky130_fd_sc_hd__a22o_1
X_1927_ uart_rdr\[28\] _1513_ _1494_ VGND VGND VPWR VPWR _1633_ sky130_fd_sc_hd__a21bo_1
X_2976_ _1145_ _1146_ _1151_ VGND VGND VPWR VPWR _1152_ sky130_fd_sc_hd__a21oi_4
XFILLER_0_16_146 VGND VGND VPWR VPWR sky130_fd_sc_hd__fill_2
X_3459_ clknet_leaf_7_S_AXI_ACLK _0024_ VGND VGND VPWR VPWR net118 sky130_fd_sc_hd__dfxtp_1
X_3528_ clknet_leaf_14_S_AXI_ACLK _0093_ VGND VGND VPWR VPWR TX.data_latch_next\[5\]
+ sky130_fd_sc_hd__dfxtp_1
X_1789_ TX.tx_enable _1518_ _1521_ _1522_ VGND VGND VPWR VPWR _1523_ sky130_fd_sc_hd__a22o_1
XFILLER_0_39_205 VGND VGND VPWR VPWR sky130_fd_sc_hd__fill_2
Xhold70 RX.uart_stp\[14\] VGND VGND VPWR VPWR net237 sky130_fd_sc_hd__dlygate4sd3_1
Xhold81 RX.uart_stp\[11\] VGND VGND VPWR VPWR net248 sky130_fd_sc_hd__dlygate4sd3_1
Xhold92 TX.uart_tdr\[8\] VGND VGND VPWR VPWR net259 sky130_fd_sc_hd__dlygate4sd3_1
XFILLER_0_30_193 VGND VGND VPWR VPWR sky130_fd_sc_hd__decap_3
X_2830_ _0348_ _0897_ RX.baud_cnt\[21\] _0579_ VGND VGND VPWR VPWR _1007_ sky130_fd_sc_hd__a22o_1
XANTENNA_1 S_AXI_ARADDR[30] VGND VGND VPWR VPWR sky130_fd_sc_hd__diode_2
X_2761_ _0911_ _0935_ _0937_ VGND VGND VPWR VPWR _0938_ sky130_fd_sc_hd__a21bo_1
X_2692_ _0872_ _0873_ VGND VGND VPWR VPWR _0879_ sky130_fd_sc_hd__nor2_1
XTAP_366 VGND VPWR sky130_fd_sc_hd__tapvpwrvgnd_1
XTAP_355 VGND VPWR sky130_fd_sc_hd__tapvpwrvgnd_1
XTAP_344 VGND VPWR sky130_fd_sc_hd__tapvpwrvgnd_1
X_3244_ _1327_ VGND VGND VPWR VPWR _1328_ sky130_fd_sc_hd__buf_2
XTAP_333 VGND VPWR sky130_fd_sc_hd__tapvpwrvgnd_1
XTAP_322 VGND VPWR sky130_fd_sc_hd__tapvpwrvgnd_1
XTAP_311 VGND VPWR sky130_fd_sc_hd__tapvpwrvgnd_1
XTAP_300 VGND VPWR sky130_fd_sc_hd__tapvpwrvgnd_1
X_3313_ _1342_ _1364_ _1377_ _1368_ net287 VGND VGND VPWR VPWR _0242_ sky130_fd_sc_hd__a32o_1
X_3175_ _1286_ VGND VGND VPWR VPWR _0195_ sky130_fd_sc_hd__clkbuf_1
XTAP_399 VGND VPWR sky130_fd_sc_hd__tapvpwrvgnd_1
XTAP_388 VGND VPWR sky130_fd_sc_hd__tapvpwrvgnd_1
XTAP_377 VGND VPWR sky130_fd_sc_hd__tapvpwrvgnd_1
X_2126_ RX.uart_cpb\[11\] RX.uart_cpb\[10\] VGND VGND VPWR VPWR _0337_ sky130_fd_sc_hd__or2_1
XPHY_17 VGND VGND VPWR VPWR sky130_fd_sc_hd__decap_3
XPHY_28 VGND VGND VPWR VPWR sky130_fd_sc_hd__decap_3
X_2057_ _1522_ _0291_ VGND VGND VPWR VPWR _0292_ sky130_fd_sc_hd__or2_1
X_2959_ RX.baud_cnt\[0\] _0623_ _1063_ VGND VGND VPWR VPWR _1136_ sky130_fd_sc_hd__o21ai_1
XPHY_39 VGND VGND VPWR VPWR sky130_fd_sc_hd__decap_3
XFILLER_0_50_222 VGND VGND VPWR VPWR sky130_fd_sc_hd__fill_1
XFILLER_0_35_296 VGND VGND VPWR VPWR sky130_fd_sc_hd__fill_1
X_2813_ _0748_ RX.baud_cnt\[29\] VGND VGND VPWR VPWR _0990_ sky130_fd_sc_hd__nor2_1
Xclkbuf_1_1__f_S_AXI_ACLK clknet_0_S_AXI_ACLK VGND VGND VPWR VPWR clknet_1_1__leaf_S_AXI_ACLK
+ sky130_fd_sc_hd__clkbuf_16
XFILLER_0_5_113 VGND VGND VPWR VPWR sky130_fd_sc_hd__fill_1
X_2744_ RX.baud_cnt\[4\] _0359_ _0358_ RX.baud_cnt\[5\] VGND VGND VPWR VPWR _0921_
+ sky130_fd_sc_hd__o22a_1
X_2675_ _0776_ _0862_ VGND VGND VPWR VPWR _0864_ sky130_fd_sc_hd__and2b_1
X_3227_ _1315_ VGND VGND VPWR VPWR _1318_ sky130_fd_sc_hd__buf_2
XTAP_152 VGND VPWR sky130_fd_sc_hd__tapvpwrvgnd_1
XTAP_141 VGND VPWR sky130_fd_sc_hd__tapvpwrvgnd_1
XTAP_130 VGND VPWR sky130_fd_sc_hd__tapvpwrvgnd_1
XTAP_163 VGND VPWR sky130_fd_sc_hd__tapvpwrvgnd_1
XTAP_174 VGND VPWR sky130_fd_sc_hd__tapvpwrvgnd_1
XTAP_185 VGND VPWR sky130_fd_sc_hd__tapvpwrvgnd_1
XTAP_196 VGND VPWR sky130_fd_sc_hd__tapvpwrvgnd_1
X_3158_ net201 VGND VGND VPWR VPWR _1278_ sky130_fd_sc_hd__clkbuf_1
XFILLER_0_49_333 VGND VGND VPWR VPWR sky130_fd_sc_hd__decap_3
X_2109_ net81 _0323_ _0326_ _0321_ VGND VGND VPWR VPWR _0089_ sky130_fd_sc_hd__o211a_1
X_3089_ _1158_ _1232_ _1234_ _1153_ RX.baud_cnt\[29\] VGND VGND VPWR VPWR _0161_ sky130_fd_sc_hd__a32o_1
XFILLER_0_27_90 VGND VGND VPWR VPWR sky130_fd_sc_hd__decap_4
X_2460_ _1562_ VGND VGND VPWR VPWR _0649_ sky130_fd_sc_hd__inv_2
XFILLER_0_23_222 VGND VGND VPWR VPWR sky130_fd_sc_hd__fill_2
XFILLER_0_48_67 VGND VGND VPWR VPWR sky130_fd_sc_hd__fill_1
X_2391_ RX.uart_stp\[1\] RX.uart_stp\[0\] VGND VGND VPWR VPWR _0580_ sky130_fd_sc_hd__nor2_1
X_3012_ _1159_ _1177_ _1179_ _1178_ RX.baud_cnt\[7\] VGND VGND VPWR VPWR _0139_ sky130_fd_sc_hd__a32o_1
X_2589_ _0693_ VGND VGND VPWR VPWR _0778_ sky130_fd_sc_hd__inv_2
XFILLER_0_14_244 VGND VGND VPWR VPWR sky130_fd_sc_hd__fill_2
XFILLER_0_14_299 VGND VGND VPWR VPWR sky130_fd_sc_hd__fill_1
X_2727_ RX.baud_cnt\[19\] VGND VGND VPWR VPWR _0904_ sky130_fd_sc_hd__buf_2
X_2658_ _0804_ _0843_ _0844_ _0846_ VGND VGND VPWR VPWR _0847_ sky130_fd_sc_hd__o211ai_1
Xfanout157 net158 VGND VGND VPWR VPWR net157 sky130_fd_sc_hd__clkbuf_4
XFILLER_0_20_203 VGND VGND VPWR VPWR sky130_fd_sc_hd__fill_2
XFILLER_0_18_48 VGND VGND VPWR VPWR sky130_fd_sc_hd__decap_4
XFILLER_0_20_247 VGND VGND VPWR VPWR sky130_fd_sc_hd__fill_2
X_1891_ _1508_ VGND VGND VPWR VPWR _1605_ sky130_fd_sc_hd__clkbuf_4
X_3630_ clknet_leaf_2_S_AXI_ACLK _0195_ net155 VGND VGND VPWR VPWR RX.rx_shifter\[28\]
+ sky130_fd_sc_hd__dfrtp_1
X_1960_ _1658_ VGND VGND VPWR VPWR _0043_ sky130_fd_sc_hd__clkbuf_1
X_3492_ clknet_leaf_7_S_AXI_ACLK _0057_ VGND VGND VPWR VPWR uart_rdr\[17\] sky130_fd_sc_hd__dfxtp_1
X_3561_ clknet_leaf_1_S_AXI_ACLK _0126_ VGND VGND VPWR VPWR RX.uart_stp\[21\] sky130_fd_sc_hd__dfxtp_1
X_2512_ _0419_ _0313_ _0604_ _0352_ _0700_ VGND VGND VPWR VPWR _0701_ sky130_fd_sc_hd__o221a_2
X_2443_ _0630_ _0519_ _0631_ _0625_ VGND VGND VPWR VPWR _0632_ sky130_fd_sc_hd__o211a_1
XFILLER_0_11_236 VPWR VGND VPWR VGND sky130_ef_sc_hd__decap_12
X_2374_ _0350_ _0352_ VGND VGND VPWR VPWR _0563_ sky130_fd_sc_hd__nor2_1
XFILLER_0_24_80 VGND VGND VPWR VPWR sky130_fd_sc_hd__decap_4
XFILLER_0_4_90 VGND VGND VPWR VPWR sky130_fd_sc_hd__fill_2
XFILLER_0_37_177 VGND VGND VPWR VPWR sky130_fd_sc_hd__decap_3
X_2090_ net272 _0310_ VGND VGND VPWR VPWR _0315_ sky130_fd_sc_hd__or2_1
X_2992_ _1018_ _1162_ VGND VGND VPWR VPWR _1165_ sky130_fd_sc_hd__nand2_1
XFILLER_0_0_48 VGND VGND VPWR VPWR sky130_fd_sc_hd__decap_8
X_1874_ RX.uart_cpb\[16\] _1578_ _1589_ _1591_ VGND VGND VPWR VPWR _1592_ sky130_fd_sc_hd__a211o_1
X_3613_ clknet_leaf_8_S_AXI_ACLK _0178_ net161 VGND VGND VPWR VPWR RX.rx_shifter\[11\]
+ sky130_fd_sc_hd__dfrtp_1
X_1943_ net174 _1534_ _1635_ _1645_ VGND VGND VPWR VPWR _0039_ sky130_fd_sc_hd__o211a_1
XFILLER_0_3_222 VGND VGND VPWR VPWR sky130_fd_sc_hd__fill_2
XFILLER_0_3_211 VGND VGND VPWR VPWR sky130_fd_sc_hd__fill_1
X_3544_ clknet_leaf_2_S_AXI_ACLK _0109_ VGND VGND VPWR VPWR TX.uart_tdr\[23\] sky130_fd_sc_hd__dfxtp_1
X_3475_ clknet_leaf_9_S_AXI_ACLK _0040_ VGND VGND VPWR VPWR uart_rdr\[0\] sky130_fd_sc_hd__dfxtp_1
X_2426_ _0335_ _0516_ _0613_ VGND VGND VPWR VPWR _0615_ sky130_fd_sc_hd__a21o_1
X_2288_ net80 _0483_ _0489_ _0487_ VGND VGND VPWR VPWR _0105_ sky130_fd_sc_hd__o211a_1
X_2357_ _0544_ _0545_ VGND VGND VPWR VPWR _0546_ sky130_fd_sc_hd__nand2_1
XFILLER_0_42_180 VGND VGND VPWR VPWR sky130_fd_sc_hd__fill_2
XFILLER_0_56_12 VGND VGND VPWR VPWR sky130_fd_sc_hd__decap_6
X_3260_ net93 _1328_ _1337_ _1336_ VGND VGND VPWR VPWR _0229_ sky130_fd_sc_hd__o211a_1
XFILLER_0_0_236 VGND VGND VPWR VPWR sky130_fd_sc_hd__fill_2
X_3191_ _1296_ VGND VGND VPWR VPWR _0201_ sky130_fd_sc_hd__clkbuf_1
X_2142_ _0341_ _0342_ _0343_ VGND VGND VPWR VPWR _0353_ sky130_fd_sc_hd__or3_2
X_2073_ net97 _0291_ _0302_ VGND VGND VPWR VPWR _0077_ sky130_fd_sc_hd__a21o_1
X_2211_ TX.baud_counter\[18\] _0416_ _0421_ TX.baud_counter\[19\] VGND VGND VPWR VPWR
+ _0422_ sky130_fd_sc_hd__a22o_1
XFILLER_0_56_250 VGND VGND VPWR VPWR sky130_fd_sc_hd__fill_2
X_2975_ RX.state\[0\] RX.state\[1\] VGND VGND VPWR VPWR _1151_ sky130_fd_sc_hd__nand2_1
X_1857_ _1520_ VGND VGND VPWR VPWR _1578_ sky130_fd_sc_hd__clkbuf_4
X_1926_ TX.uart_tdr\[28\] _1604_ _1605_ RX.uart_stp\[28\] VGND VGND VPWR VPWR _1632_
+ sky130_fd_sc_hd__a22o_1
XFILLER_0_24_191 VGND VGND VPWR VPWR sky130_fd_sc_hd__decap_4
X_1788_ RX.uart_cpb\[0\] VGND VGND VPWR VPWR _1522_ sky130_fd_sc_hd__buf_2
X_3527_ clknet_leaf_14_S_AXI_ACLK _0092_ VGND VGND VPWR VPWR TX.data_latch_next\[4\]
+ sky130_fd_sc_hd__dfxtp_1
X_3458_ clknet_leaf_6_S_AXI_ACLK _0023_ VGND VGND VPWR VPWR net117 sky130_fd_sc_hd__dfxtp_1
X_2409_ _0403_ _1526_ _0582_ _0404_ VGND VGND VPWR VPWR _0598_ sky130_fd_sc_hd__a22o_1
X_3389_ TX.baud_counter\[28\] _1429_ TX.baud_counter\[29\] VGND VGND VPWR VPWR _1433_
+ sky130_fd_sc_hd__a21oi_1
Xclkbuf_leaf_22_S_AXI_ACLK clknet_1_0__leaf_S_AXI_ACLK VGND VGND VPWR VPWR clknet_leaf_22_S_AXI_ACLK
+ sky130_fd_sc_hd__clkbuf_16
Xhold60 RX.rx_shifter\[23\] VGND VGND VPWR VPWR net227 sky130_fd_sc_hd__dlygate4sd3_1
Xhold93 TX.uart_tdr\[26\] VGND VGND VPWR VPWR net260 sky130_fd_sc_hd__dlygate4sd3_1
Xhold71 TX.uart_tdr\[24\] VGND VGND VPWR VPWR net238 sky130_fd_sc_hd__dlygate4sd3_1
Xhold82 RX.uart_stp\[15\] VGND VGND VPWR VPWR net249 sky130_fd_sc_hd__dlygate4sd3_1
XANTENNA_2 _1470_ VGND VGND VPWR VPWR sky130_fd_sc_hd__diode_2
X_2691_ net182 _1646_ _1635_ _0878_ VGND VGND VPWR VPWR _0119_ sky130_fd_sc_hd__o211a_1
X_2760_ RX.baud_cnt\[14\] _0400_ _0406_ _0936_ VGND VGND VPWR VPWR _0937_ sky130_fd_sc_hd__o22a_1
XTAP_389 VGND VPWR sky130_fd_sc_hd__tapvpwrvgnd_1
XTAP_378 VGND VPWR sky130_fd_sc_hd__tapvpwrvgnd_1
XTAP_367 VGND VPWR sky130_fd_sc_hd__tapvpwrvgnd_1
X_3243_ _1480_ _0307_ VGND VGND VPWR VPWR _1327_ sky130_fd_sc_hd__or2_1
XTAP_356 VGND VPWR sky130_fd_sc_hd__tapvpwrvgnd_1
XTAP_345 VGND VPWR sky130_fd_sc_hd__tapvpwrvgnd_1
XTAP_334 VGND VPWR sky130_fd_sc_hd__tapvpwrvgnd_1
XTAP_323 VGND VPWR sky130_fd_sc_hd__tapvpwrvgnd_1
XTAP_312 VGND VPWR sky130_fd_sc_hd__tapvpwrvgnd_1
XTAP_301 VGND VPWR sky130_fd_sc_hd__tapvpwrvgnd_1
X_3312_ _1375_ _1376_ VGND VGND VPWR VPWR _1377_ sky130_fd_sc_hd__nor2_1
X_3174_ net231 VGND VGND VPWR VPWR _1286_ sky130_fd_sc_hd__clkbuf_1
X_2056_ _0287_ _0288_ VGND VGND VPWR VPWR _0291_ sky130_fd_sc_hd__nor2_2
XPHY_18 VGND VGND VPWR VPWR sky130_fd_sc_hd__decap_3
X_2125_ _1545_ _1541_ _0334_ _0335_ VGND VGND VPWR VPWR _0336_ sky130_fd_sc_hd__or4_4
XPHY_29 VGND VGND VPWR VPWR sky130_fd_sc_hd__decap_3
X_1909_ TX.uart_tdr\[24\] _1604_ _1605_ RX.uart_stp\[24\] VGND VGND VPWR VPWR _1619_
+ sky130_fd_sc_hd__a22o_1
X_2958_ _1127_ _1129_ _1133_ _1134_ VGND VGND VPWR VPWR _1135_ sky130_fd_sc_hd__o31ai_1
X_2889_ _0922_ _0808_ VGND VGND VPWR VPWR _1066_ sky130_fd_sc_hd__nand2_1
XFILLER_0_2_309 VPWR VGND VPWR VGND sky130_ef_sc_hd__decap_12
XFILLER_0_37_25 VGND VGND VPWR VPWR sky130_fd_sc_hd__fill_1
X_2812_ RX.baud_cnt\[28\] VGND VGND VPWR VPWR _0989_ sky130_fd_sc_hd__inv_2
XFILLER_0_5_125 VGND VGND VPWR VPWR sky130_fd_sc_hd__fill_1
X_2743_ RX.baud_cnt\[6\] _0372_ _0376_ RX.baud_cnt\[7\] VGND VGND VPWR VPWR _0920_
+ sky130_fd_sc_hd__o22a_1
XFILLER_0_26_286 VGND VGND VPWR VPWR sky130_fd_sc_hd__fill_1
X_2674_ TX.baud_counter\[24\] _0773_ _0776_ _0860_ _0862_ VGND VGND VPWR VPWR _0863_
+ sky130_fd_sc_hd__o2111a_1
X_3157_ _1277_ VGND VGND VPWR VPWR _0186_ sky130_fd_sc_hd__clkbuf_1
X_3226_ _1317_ VGND VGND VPWR VPWR _0215_ sky130_fd_sc_hd__clkbuf_1
XTAP_153 VGND VPWR sky130_fd_sc_hd__tapvpwrvgnd_1
XTAP_142 VGND VPWR sky130_fd_sc_hd__tapvpwrvgnd_1
XTAP_120 VGND VPWR sky130_fd_sc_hd__tapvpwrvgnd_1
XTAP_131 VGND VPWR sky130_fd_sc_hd__tapvpwrvgnd_1
XTAP_164 VGND VPWR sky130_fd_sc_hd__tapvpwrvgnd_1
XTAP_175 VGND VPWR sky130_fd_sc_hd__tapvpwrvgnd_1
XTAP_186 VGND VPWR sky130_fd_sc_hd__tapvpwrvgnd_1
XTAP_197 VGND VPWR sky130_fd_sc_hd__tapvpwrvgnd_1
X_2039_ RX.done_reg RX.rx_shifter\[28\] _1695_ uart_rdr\[28\] VGND VGND VPWR VPWR
+ _1713_ sky130_fd_sc_hd__a22o_1
X_2108_ net311 _0324_ VGND VGND VPWR VPWR _0326_ sky130_fd_sc_hd__or2_1
X_3088_ _0974_ _1233_ VGND VGND VPWR VPWR _1234_ sky130_fd_sc_hd__nor2_1
XFILLER_0_32_212 VGND VGND VPWR VPWR sky130_fd_sc_hd__decap_3
XFILLER_0_55_337 VPWR VGND VPWR VGND sky130_ef_sc_hd__decap_12
X_2390_ RX.uart_cpb\[22\] VGND VGND VPWR VPWR _0579_ sky130_fd_sc_hd__inv_2
XFILLER_0_3_15 VPWR VGND VPWR VGND sky130_ef_sc_hd__decap_12
X_3011_ RX.baud_cnt\[7\] _1160_ VGND VGND VPWR VPWR _1179_ sky130_fd_sc_hd__nor2_1
X_2726_ RX.baud_cnt\[16\] _0409_ _0414_ _0902_ VGND VGND VPWR VPWR _0903_ sky130_fd_sc_hd__o22a_1
X_2588_ _0690_ _0699_ _0701_ VGND VGND VPWR VPWR _0777_ sky130_fd_sc_hd__nand3_2
Xfanout147 net148 VGND VGND VPWR VPWR net147 sky130_fd_sc_hd__clkbuf_4
X_2657_ TX.baud_counter\[14\] _0845_ VGND VGND VPWR VPWR _0846_ sky130_fd_sc_hd__nand2_1
X_3209_ net78 _1305_ _1307_ _1302_ VGND VGND VPWR VPWR _0208_ sky130_fd_sc_hd__o211a_1
Xfanout158 net163 VGND VGND VPWR VPWR net158 sky130_fd_sc_hd__buf_4
XFILLER_0_51_340 VPWR VGND VPWR VGND sky130_ef_sc_hd__decap_12
XFILLER_0_50_14 VGND VGND VPWR VPWR sky130_fd_sc_hd__fill_1
X_1890_ _1506_ VGND VGND VPWR VPWR _1604_ sky130_fd_sc_hd__clkbuf_4
X_3560_ clknet_leaf_0_S_AXI_ACLK _0125_ VGND VGND VPWR VPWR RX.uart_stp\[20\] sky130_fd_sc_hd__dfxtp_1
X_3491_ clknet_leaf_8_S_AXI_ACLK _0056_ VGND VGND VPWR VPWR uart_rdr\[16\] sky130_fd_sc_hd__dfxtp_1
X_2373_ _0352_ _0419_ _0559_ _0561_ _0555_ VGND VGND VPWR VPWR _0562_ sky130_fd_sc_hd__o221a_1
X_2511_ _0560_ _0562_ _0694_ _0589_ _0695_ VGND VGND VPWR VPWR _0700_ sky130_fd_sc_hd__a311o_1
X_2442_ _1535_ _1532_ VGND VGND VPWR VPWR _0631_ sky130_fd_sc_hd__nand2_1
X_2709_ net82 _0883_ _0889_ _0890_ VGND VGND VPWR VPWR _0125_ sky130_fd_sc_hd__o211a_1
X_3689_ clknet_leaf_20_S_AXI_ACLK _0254_ net148 VGND VGND VPWR VPWR TX.baud_counter\[20\]
+ sky130_fd_sc_hd__dfrtp_4
XFILLER_0_45_36 VGND VGND VPWR VPWR sky130_fd_sc_hd__decap_4
X_1942_ RX.uart_cpb\[31\] _1521_ _1643_ _1644_ VGND VGND VPWR VPWR _1645_ sky130_fd_sc_hd__a211o_1
X_2991_ _1159_ _1162_ _1164_ _1154_ RX.baud_cnt\[1\] VGND VGND VPWR VPWR _0133_ sky130_fd_sc_hd__a32o_1
X_1873_ uart_rdr\[16\] _1580_ _1590_ VGND VGND VPWR VPWR _1591_ sky130_fd_sc_hd__a21bo_1
X_3543_ clknet_leaf_1_S_AXI_ACLK _0108_ VGND VGND VPWR VPWR TX.uart_tdr\[22\] sky130_fd_sc_hd__dfxtp_1
X_3612_ clknet_leaf_9_S_AXI_ACLK _0177_ net161 VGND VGND VPWR VPWR RX.rx_shifter\[10\]
+ sky130_fd_sc_hd__dfrtp_1
XFILLER_0_50_6 VGND VGND VPWR VPWR sky130_fd_sc_hd__decap_8
X_3474_ clknet_leaf_10_S_AXI_ACLK _0039_ VGND VGND VPWR VPWR net135 sky130_fd_sc_hd__dfxtp_1
X_2356_ RX.uart_cpb\[15\] RX.uart_cpb\[14\] VGND VGND VPWR VPWR _0545_ sky130_fd_sc_hd__or2_1
X_2425_ _0335_ _0516_ _0613_ VGND VGND VPWR VPWR _0614_ sky130_fd_sc_hd__nand3_2
X_2287_ net236 _0484_ VGND VGND VPWR VPWR _0489_ sky130_fd_sc_hd__or2_1
XFILLER_0_29_3 VGND VGND VPWR VPWR sky130_fd_sc_hd__decap_4
XFILLER_0_34_148 VGND VGND VPWR VPWR sky130_fd_sc_hd__decap_3
XFILLER_0_19_167 VGND VGND VPWR VPWR sky130_fd_sc_hd__fill_1
Xclkbuf_leaf_12_S_AXI_ACLK clknet_1_1__leaf_S_AXI_ACLK VGND VGND VPWR VPWR clknet_leaf_12_S_AXI_ACLK
+ sky130_fd_sc_hd__clkbuf_16
XFILLER_0_56_35 VPWR VGND VPWR VGND sky130_ef_sc_hd__decap_12
X_3190_ _0295_ _1295_ VGND VGND VPWR VPWR _1296_ sky130_fd_sc_hd__and2_1
X_2210_ _0419_ _0420_ _0353_ VGND VGND VPWR VPWR _0421_ sky130_fd_sc_hd__o21a_1
X_2141_ RX.uart_cpb\[20\] VGND VGND VPWR VPWR _0352_ sky130_fd_sc_hd__inv_2
X_2072_ _1545_ _0290_ _1485_ VGND VGND VPWR VPWR _0302_ sky130_fd_sc_hd__a21bo_1
X_1925_ _1609_ net221 _1600_ _1631_ VGND VGND VPWR VPWR _0035_ sky130_fd_sc_hd__o211a_1
X_2974_ RX.state\[1\] VGND VGND VPWR VPWR _1150_ sky130_fd_sc_hd__inv_2
X_1856_ _1571_ net189 _1561_ _1577_ VGND VGND VPWR VPWR _0020_ sky130_fd_sc_hd__o211a_1
XFILLER_0_31_118 VGND VGND VPWR VPWR sky130_fd_sc_hd__decap_8
X_3526_ clknet_leaf_12_S_AXI_ACLK _0091_ VGND VGND VPWR VPWR TX.data_latch_next\[3\]
+ sky130_fd_sc_hd__dfxtp_1
XFILLER_0_16_159 VGND VGND VPWR VPWR sky130_fd_sc_hd__fill_2
X_1787_ _1520_ VGND VGND VPWR VPWR _1521_ sky130_fd_sc_hd__clkbuf_4
X_3457_ clknet_leaf_8_S_AXI_ACLK _0022_ VGND VGND VPWR VPWR net116 sky130_fd_sc_hd__dfxtp_1
X_2408_ _0543_ _0544_ _0595_ VGND VGND VPWR VPWR _0597_ sky130_fd_sc_hd__nand3b_1
X_3388_ TX.baud_counter\[28\] _1355_ _1350_ _1432_ VGND VGND VPWR VPWR _0262_ sky130_fd_sc_hd__a22o_1
X_2339_ RX.uart_cpb\[8\] RX.uart_cpb\[6\] _1553_ VGND VGND VPWR VPWR _0528_ sky130_fd_sc_hd__o21a_1
Xhold50 RX.rx_shifter\[26\] VGND VGND VPWR VPWR net217 sky130_fd_sc_hd__dlygate4sd3_1
Xhold61 RX.rx_shifter\[17\] VGND VGND VPWR VPWR net228 sky130_fd_sc_hd__dlygate4sd3_1
Xhold72 RX.rx_shifter\[14\] VGND VGND VPWR VPWR net239 sky130_fd_sc_hd__dlygate4sd3_1
Xhold83 RX.uart_stp\[19\] VGND VGND VPWR VPWR net250 sky130_fd_sc_hd__dlygate4sd3_1
Xhold94 TX.baud_counter\[24\] VGND VGND VPWR VPWR net261 sky130_fd_sc_hd__dlygate4sd3_1
XANTENNA_3 _1589_ VGND VGND VPWR VPWR sky130_fd_sc_hd__diode_2
X_2690_ _1647_ VGND VGND VPWR VPWR _0878_ sky130_fd_sc_hd__inv_2
X_3311_ TX.baud_counter\[7\] TX.baud_counter\[8\] _1371_ VGND VGND VPWR VPWR _1376_
+ sky130_fd_sc_hd__and3_1
X_3173_ _1285_ VGND VGND VPWR VPWR _0194_ sky130_fd_sc_hd__clkbuf_1
XTAP_379 VGND VPWR sky130_fd_sc_hd__tapvpwrvgnd_1
XTAP_368 VGND VPWR sky130_fd_sc_hd__tapvpwrvgnd_1
X_3242_ net76 _1318_ _1326_ _1322_ VGND VGND VPWR VPWR _0222_ sky130_fd_sc_hd__o211a_1
XTAP_357 VGND VPWR sky130_fd_sc_hd__tapvpwrvgnd_1
XTAP_346 VGND VPWR sky130_fd_sc_hd__tapvpwrvgnd_1
XTAP_335 VGND VPWR sky130_fd_sc_hd__tapvpwrvgnd_1
XTAP_324 VGND VPWR sky130_fd_sc_hd__tapvpwrvgnd_1
XTAP_313 VGND VPWR sky130_fd_sc_hd__tapvpwrvgnd_1
XTAP_302 VGND VPWR sky130_fd_sc_hd__tapvpwrvgnd_1
X_2124_ RX.uart_cpb\[7\] RX.uart_cpb\[6\] VGND VGND VPWR VPWR _0335_ sky130_fd_sc_hd__or2_2
X_2055_ _0289_ VGND VGND VPWR VPWR _0290_ sky130_fd_sc_hd__buf_2
XPHY_19 VGND VGND VPWR VPWR sky130_fd_sc_hd__decap_3
X_1908_ _1609_ net321 _1600_ _1618_ VGND VGND VPWR VPWR _0031_ sky130_fd_sc_hd__o211a_1
X_1839_ uart_rdr\[9\] _1538_ _1550_ VGND VGND VPWR VPWR _1564_ sky130_fd_sc_hd__a21bo_1
X_2957_ RX.baud_cnt\[30\] _0767_ _1130_ _1131_ _1128_ VGND VGND VPWR VPWR _1134_ sky130_fd_sc_hd__a221o_1
XFILLER_0_4_351 VGND VGND VPWR VPWR sky130_fd_sc_hd__fill_1
X_2888_ _1062_ _1063_ _1064_ VGND VGND VPWR VPWR _1065_ sky130_fd_sc_hd__a21o_1
XFILLER_0_8_134 VGND VGND VPWR VPWR sky130_fd_sc_hd__fill_1
X_3509_ clknet_leaf_15_S_AXI_ACLK _0074_ VGND VGND VPWR VPWR RX.uart_cpb\[2\] sky130_fd_sc_hd__dfxtp_1
XFILLER_0_12_195 VGND VGND VPWR VPWR sky130_fd_sc_hd__fill_1
Xclkbuf_leaf_2_S_AXI_ACLK clknet_1_0__leaf_S_AXI_ACLK VGND VGND VPWR VPWR clknet_leaf_2_S_AXI_ACLK
+ sky130_fd_sc_hd__clkbuf_16
XFILLER_0_12_29 VGND VGND VPWR VPWR sky130_fd_sc_hd__fill_1
X_2811_ _0449_ RX.baud_cnt\[30\] VGND VGND VPWR VPWR _0988_ sky130_fd_sc_hd__and2_1
X_2742_ RX.baud_cnt\[7\] _0376_ VGND VGND VPWR VPWR _0919_ sky130_fd_sc_hd__nand2_1
XTAP_132 VGND VPWR sky130_fd_sc_hd__tapvpwrvgnd_1
XTAP_121 VGND VPWR sky130_fd_sc_hd__tapvpwrvgnd_1
X_2673_ TX.baud_counter\[26\] _0861_ _0775_ TX.baud_counter\[25\] VGND VGND VPWR VPWR
+ _0862_ sky130_fd_sc_hd__o22a_1
X_3156_ net220 VGND VGND VPWR VPWR _1277_ sky130_fd_sc_hd__clkbuf_1
X_3225_ _0295_ _1316_ VGND VGND VPWR VPWR _1317_ sky130_fd_sc_hd__and2_1
X_2107_ net70 _0323_ _0325_ _0321_ VGND VGND VPWR VPWR _0088_ sky130_fd_sc_hd__o211a_1
X_3087_ RX.baud_cnt\[29\] _1230_ VGND VGND VPWR VPWR _1233_ sky130_fd_sc_hd__and2_1
XTAP_154 VGND VPWR sky130_fd_sc_hd__tapvpwrvgnd_1
XTAP_143 VGND VPWR sky130_fd_sc_hd__tapvpwrvgnd_1
XTAP_165 VGND VPWR sky130_fd_sc_hd__tapvpwrvgnd_1
XTAP_176 VGND VPWR sky130_fd_sc_hd__tapvpwrvgnd_1
XTAP_187 VGND VPWR sky130_fd_sc_hd__tapvpwrvgnd_1
XTAP_198 VGND VPWR sky130_fd_sc_hd__tapvpwrvgnd_1
X_2038_ _1712_ VGND VGND VPWR VPWR _0067_ sky130_fd_sc_hd__clkbuf_1
XFILLER_0_49_357 VGND VGND VPWR VPWR sky130_fd_sc_hd__fill_1
XFILLER_0_11_3 VPWR VGND VPWR VGND sky130_ef_sc_hd__decap_12
XFILLER_0_55_349 VGND VGND VPWR VPWR sky130_fd_sc_hd__decap_8
XFILLER_0_23_279 VGND VGND VPWR VPWR sky130_fd_sc_hd__fill_1
XFILLER_0_23_235 VGND VGND VPWR VPWR sky130_fd_sc_hd__fill_2
XFILLER_0_3_27 VPWR VGND VPWR VGND sky130_ef_sc_hd__decap_12
X_3010_ net302 _1175_ _1178_ VGND VGND VPWR VPWR _0138_ sky130_fd_sc_hd__o21a_1
X_2656_ _0800_ _0674_ VGND VGND VPWR VPWR _0845_ sky130_fd_sc_hd__xnor2_2
XFILLER_0_13_72 VGND VGND VPWR VPWR sky130_fd_sc_hd__fill_1
X_2725_ RX.baud_cnt\[17\] VGND VGND VPWR VPWR _0902_ sky130_fd_sc_hd__buf_2
Xfanout159 net162 VGND VGND VPWR VPWR net159 sky130_fd_sc_hd__clkbuf_4
X_2587_ TX.baud_counter\[25\] _0775_ _0773_ TX.baud_counter\[24\] VGND VGND VPWR VPWR
+ _0776_ sky130_fd_sc_hd__a22oi_2
XFILLER_0_1_184 VGND VGND VPWR VPWR sky130_fd_sc_hd__fill_1
Xfanout148 net149 VGND VGND VPWR VPWR net148 sky130_fd_sc_hd__buf_2
X_3139_ _1268_ VGND VGND VPWR VPWR _0177_ sky130_fd_sc_hd__clkbuf_1
X_3208_ _1002_ _1305_ VGND VGND VPWR VPWR _1307_ sky130_fd_sc_hd__nand2_1
XFILLER_0_9_251 VGND VGND VPWR VPWR sky130_fd_sc_hd__fill_2
XFILLER_0_51_363 VGND VGND VPWR VPWR sky130_fd_sc_hd__fill_1
XFILLER_0_51_352 VGND VGND VPWR VPWR sky130_fd_sc_hd__fill_2
X_3490_ clknet_leaf_8_S_AXI_ACLK _0055_ VGND VGND VPWR VPWR uart_rdr\[15\] sky130_fd_sc_hd__dfxtp_1
X_2510_ _0577_ _0696_ _0697_ _0698_ VGND VGND VPWR VPWR _0699_ sky130_fd_sc_hd__a31o_1
X_2372_ _1596_ RX.uart_cpb\[16\] RX.uart_cpb\[17\] VGND VGND VPWR VPWR _0561_ sky130_fd_sc_hd__o21ai_1
X_2441_ _1541_ RX.uart_cpb\[3\] VGND VGND VPWR VPWR _0630_ sky130_fd_sc_hd__and2_1
XFILLER_0_46_179 VGND VGND VPWR VPWR sky130_fd_sc_hd__fill_1
X_2708_ _0295_ VGND VGND VPWR VPWR _0890_ sky130_fd_sc_hd__clkbuf_4
X_3688_ clknet_leaf_20_S_AXI_ACLK _0253_ net147 VGND VGND VPWR VPWR TX.baud_counter\[19\]
+ sky130_fd_sc_hd__dfrtp_4
X_2639_ _0822_ _0824_ _0826_ TX.baud_counter\[6\] _0827_ VGND VGND VPWR VPWR _0828_
+ sky130_fd_sc_hd__o221a_1
XFILLER_0_10_293 VGND VGND VPWR VPWR sky130_fd_sc_hd__fill_1
XFILLER_0_37_102 VGND VGND VPWR VPWR sky130_fd_sc_hd__fill_1
XFILLER_0_20_29 VGND VGND VPWR VPWR sky130_fd_sc_hd__fill_1
X_1872_ net108 VGND VGND VPWR VPWR _1590_ sky130_fd_sc_hd__buf_2
X_1941_ uart_rdr\[31\] _1513_ _1494_ VGND VGND VPWR VPWR _1644_ sky130_fd_sc_hd__a21bo_1
X_2990_ RX.baud_cnt\[1\] RX.baud_cnt\[0\] _1163_ VGND VGND VPWR VPWR _1164_ sky130_fd_sc_hd__o21a_1
X_3542_ clknet_leaf_1_S_AXI_ACLK _0107_ VGND VGND VPWR VPWR TX.uart_tdr\[21\] sky130_fd_sc_hd__dfxtp_1
X_3611_ clknet_leaf_9_S_AXI_ACLK _0176_ net161 VGND VGND VPWR VPWR RX.rx_shifter\[9\]
+ sky130_fd_sc_hd__dfrtp_1
X_3473_ clknet_leaf_0_S_AXI_ACLK _0038_ VGND VGND VPWR VPWR net134 sky130_fd_sc_hd__dfxtp_1
XFILLER_0_24_363 VGND VGND VPWR VPWR sky130_fd_sc_hd__fill_1
X_2286_ net79 _0483_ _0488_ _0487_ VGND VGND VPWR VPWR _0104_ sky130_fd_sc_hd__o211a_1
X_2355_ RX.uart_cpb\[15\] RX.uart_cpb\[14\] VGND VGND VPWR VPWR _0544_ sky130_fd_sc_hd__nand2_1
X_2424_ _0523_ _0526_ _0527_ VGND VGND VPWR VPWR _0613_ sky130_fd_sc_hd__a21o_1
XFILLER_0_15_352 VGND VGND VPWR VPWR sky130_fd_sc_hd__decap_4
XFILLER_0_56_47 VGND VGND VPWR VPWR sky130_fd_sc_hd__fill_1
X_2140_ _0350_ _0344_ VGND VGND VPWR VPWR _0351_ sky130_fd_sc_hd__xnor2_2
X_2071_ net96 _0290_ _0301_ _0296_ VGND VGND VPWR VPWR _0076_ sky130_fd_sc_hd__o211a_1
X_1855_ RX.uart_cpb\[12\] _1536_ _1575_ _1576_ VGND VGND VPWR VPWR _1577_ sky130_fd_sc_hd__a211o_1
X_1924_ RX.uart_cpb\[27\] _1521_ _1629_ _1630_ VGND VGND VPWR VPWR _1631_ sky130_fd_sc_hd__a211o_1
X_2973_ _1149_ VGND VGND VPWR VPWR _0130_ sky130_fd_sc_hd__clkbuf_1
XFILLER_0_21_50 VGND VGND VPWR VPWR sky130_fd_sc_hd__fill_1
X_3456_ clknet_leaf_7_S_AXI_ACLK _0021_ VGND VGND VPWR VPWR net115 sky130_fd_sc_hd__dfxtp_1
X_1786_ _1519_ _1517_ VGND VGND VPWR VPWR _1520_ sky130_fd_sc_hd__nor2_2
X_3525_ clknet_leaf_14_S_AXI_ACLK _0090_ VGND VGND VPWR VPWR TX.data_latch_next\[2\]
+ sky130_fd_sc_hd__dfxtp_1
X_2407_ _0544_ _0595_ _0543_ VGND VGND VPWR VPWR _0596_ sky130_fd_sc_hd__a21bo_1
X_2269_ TX.state\[1\] _0476_ _0477_ VGND VGND VPWR VPWR _0098_ sky130_fd_sc_hd__o21a_1
X_3387_ TX.baud_counter\[28\] _1429_ _1431_ VGND VGND VPWR VPWR _1432_ sky130_fd_sc_hd__o21a_1
X_2338_ RX.uart_cpb\[6\] RX.uart_cpb\[4\] RX.uart_cpb\[5\] VGND VGND VPWR VPWR _0527_
+ sky130_fd_sc_hd__o21a_1
Xhold40 RX.rx_shifter\[10\] VGND VGND VPWR VPWR net207 sky130_fd_sc_hd__dlygate4sd3_1
XFILLER_0_30_141 VGND VGND VPWR VPWR sky130_fd_sc_hd__decap_8
Xhold95 RX.rx_shifter\[29\] VGND VGND VPWR VPWR net262 sky130_fd_sc_hd__dlygate4sd3_1
Xhold62 RX.uart_stp\[29\] VGND VGND VPWR VPWR net229 sky130_fd_sc_hd__dlygate4sd3_1
Xhold51 TX.uart_tdr\[25\] VGND VGND VPWR VPWR net218 sky130_fd_sc_hd__dlygate4sd3_1
Xhold84 net112 VGND VGND VPWR VPWR net251 sky130_fd_sc_hd__dlygate4sd3_1
Xhold73 TX.baud_counter\[5\] VGND VGND VPWR VPWR net240 sky130_fd_sc_hd__dlygate4sd3_1
XTAP_314 VGND VPWR sky130_fd_sc_hd__tapvpwrvgnd_1
XTAP_303 VGND VPWR sky130_fd_sc_hd__tapvpwrvgnd_1
XANTENNA_4 net35 VGND VGND VPWR VPWR sky130_fd_sc_hd__diode_2
XFILLER_0_6_27 VGND VGND VPWR VPWR sky130_fd_sc_hd__fill_1
X_3310_ TX.baud_counter\[7\] _1371_ TX.baud_counter\[8\] VGND VGND VPWR VPWR _1375_
+ sky130_fd_sc_hd__a21oi_1
X_3172_ net209 VGND VGND VPWR VPWR _1285_ sky130_fd_sc_hd__clkbuf_1
XTAP_369 VGND VPWR sky130_fd_sc_hd__tapvpwrvgnd_1
XTAP_358 VGND VPWR sky130_fd_sc_hd__tapvpwrvgnd_1
XTAP_347 VGND VPWR sky130_fd_sc_hd__tapvpwrvgnd_1
XTAP_336 VGND VPWR sky130_fd_sc_hd__tapvpwrvgnd_1
X_3241_ _0404_ _1315_ VGND VGND VPWR VPWR _1326_ sky130_fd_sc_hd__nand2_1
XTAP_325 VGND VPWR sky130_fd_sc_hd__tapvpwrvgnd_1
X_2123_ _1535_ _1532_ RX.uart_cpb\[1\] _1522_ VGND VGND VPWR VPWR _0334_ sky130_fd_sc_hd__or4_4
X_2054_ _0287_ _0288_ VGND VGND VPWR VPWR _0289_ sky130_fd_sc_hd__or2_1
XFILLER_0_16_83 VGND VGND VPWR VPWR sky130_fd_sc_hd__fill_1
X_1907_ RX.uart_cpb\[23\] _1521_ _1616_ _1617_ VGND VGND VPWR VPWR _1618_ sky130_fd_sc_hd__a211o_1
X_1838_ TX.uart_tdr\[9\] _1507_ _1509_ RX.uart_stp\[9\] VGND VGND VPWR VPWR _1563_
+ sky130_fd_sc_hd__a22o_1
XFILLER_0_32_82 VGND VGND VPWR VPWR sky130_fd_sc_hd__fill_2
XFILLER_0_32_60 VGND VGND VPWR VPWR sky130_fd_sc_hd__fill_1
X_2956_ _1130_ _1131_ _1132_ VGND VGND VPWR VPWR _1133_ sky130_fd_sc_hd__nand3_1
X_2887_ _0922_ _0808_ _0810_ RX.baud_cnt\[2\] VGND VGND VPWR VPWR _1064_ sky130_fd_sc_hd__o22ai_1
X_1769_ _1496_ _1497_ _1502_ VGND VGND VPWR VPWR _1503_ sky130_fd_sc_hd__nor3_1
X_3439_ clknet_leaf_4_S_AXI_ACLK _0004_ VGND VGND VPWR VPWR TX.uart_tdr\[28\] sky130_fd_sc_hd__dfxtp_1
X_3508_ clknet_leaf_15_S_AXI_ACLK _0073_ VGND VGND VPWR VPWR RX.uart_cpb\[1\] sky130_fd_sc_hd__dfxtp_4
X_2672_ _0722_ _0732_ VGND VGND VPWR VPWR _0861_ sky130_fd_sc_hd__xor2_2
X_2810_ _0748_ RX.baud_cnt\[29\] _0976_ _0985_ _0986_ VGND VGND VPWR VPWR _0987_ sky130_fd_sc_hd__o221a_1
X_2741_ _0912_ _0913_ _0917_ VGND VGND VPWR VPWR _0918_ sky130_fd_sc_hd__and3b_1
X_3224_ net100 _1557_ _1315_ VGND VGND VPWR VPWR _1316_ sky130_fd_sc_hd__mux2_1
XTAP_155 VGND VPWR sky130_fd_sc_hd__tapvpwrvgnd_1
XTAP_144 VGND VPWR sky130_fd_sc_hd__tapvpwrvgnd_1
XTAP_133 VGND VPWR sky130_fd_sc_hd__tapvpwrvgnd_1
XTAP_122 VGND VPWR sky130_fd_sc_hd__tapvpwrvgnd_1
XTAP_166 VGND VPWR sky130_fd_sc_hd__tapvpwrvgnd_1
.ends
